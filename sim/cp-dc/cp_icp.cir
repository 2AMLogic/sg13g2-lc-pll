* sg13g2-lc-pll :: sim/cp-dc -- charge-pump output current at one operating point, for `klt sim`.
* Circuit body only (klt sim owns the .control block and the .lib cards). Same two-copy arrangement
* as cp_dc.spice.tmpl: copy A has UP on / DN off (I_up), copy B has DN on / UP off (I_dn), both
* at V_out = 1.65 V (the mid-compliance point of the sim/cp-dc record). IREF = 20 uA per copy.
* The supplies VDD and VHI (UP/DN logic high) are altered together by corners.supply_v.
.option scale=1
VDD vdd 0 3.3
VHI hi 0 3.3
VA outa 0 1.65
EB nb 0 outa 0 1
VMB nb outb 0
IRA vdd irefa dc 20u
IRB vdd irefb dc 20u
XA hi 0 irefa outa vdd 0 cp
XB 0 hi irefb outb vdd 0 cp
.include ../../design/netlist/cp.spice

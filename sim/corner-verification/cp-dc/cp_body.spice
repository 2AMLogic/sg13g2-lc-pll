* sg13g2-lc-pll :: sim/corner-verification/cp-dc -- charge-pump static bench as a klt sim circuit body.
* Same circuit as sim/cp-dc/cp_dc.spice.tmpl (two cp copies, UP forced on in A, DN forced on in B,
* B's output follows A's through a unity VCVS) minus the .lib/.option/.control/.dc cards, which
* klt sim generates per corner. VDD and VHI are the supply axis (set together by index).
.include ../../../design/netlist/cp.spice
VDD vdd 0 3.3
VHI hi 0 3.3
VA outa 0 1.65
EB nb 0 outa 0 1
VMB nb outb 0
IRA vdd irefa dc 20u
IRB vdd irefb dc 20u
XA hi 0 irefa outa vdd 0 cp
XB 0 hi irefb outb vdd 0 cp

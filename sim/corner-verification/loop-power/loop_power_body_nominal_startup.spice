* PROBE ONLY (issue #70 start-up question): the nominal record's start-up (DC supplies, DC IREF, .nodeset) on the same circuit.
* sg13g2-lc-pll :: sim/corner-verification/loop-power -- spec row 11 loop power as a klt sim circuit body.
* Same circuit as sim/loop-power/loop_power.spice.tmpl (prescaler + M/A divider, N = 100, ideal 5.0 GHz
* differential drive 0.4 Vpp, 50 uA IREF) minus the .lib/.option/.control cards, which klt sim generates per
* corner. vddv is the supply axis (corners.params): the SIN common mode must move with the supply, which
* corners.supply_v cannot do (alter has no effect on a SIN source). Rails VDDP / VDDD are separate so the
* prescaler and divider currents are reported separately.
* Start-up: the DC operating point of the HBT prescaler does not converge from the powered state at most
* corners (timestep too small on the reference HBT), so supplies, IREF and the drive common mode ramp from 0 V
* over 3 ns and the t = 0 point is all zeros. The power window starts at 40 ns, well after the ramp.
.param vddv=3.3
VDDP vddp 0 {vddv}
VDDD vddd 0 {vddv}
IRF vddp iref dc 50u
VIP inp 0 dc {vddv} sin({vddv} 0.1 5.0e9)
VIN inn 0 dc {vddv} sin({vddv} -0.1 5.0e9)
.include ../../../design/netlist/prescaler.spice
.include ../../../design/netlist/divider.spice
XPS inp inn mc iref psp psn vddp 0 prescaler
XDIV psp psn iref 0 0 vddd vddd 0 0 vddd mc fb vddd 0 divider
.nodeset v(xps.hp)=3.2 v(xps.hn)=3.0 v(xps.x2.mp)=3.0 v(xps.x2.mn)=3.2

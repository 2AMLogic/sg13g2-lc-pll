* sg13g2-lc-pll :: gate G2 C-grid circuit body (loaded). Generated by make_requests.py from the sha256-verified
* fetched sg13g2-vco design/vco.spice: the VCO element lines are verbatim. Replaced: the VSUP / VCT DC values
* (now .param vddv / vctrl axes) and the .ic common mode (tracks vddv). Removed: .lib/.include/.control (klt sim writes them).
* Added: BD, the differential probe v(vd) = v(OUTP) - v(OUTN). Models: mosvar OSDI via options.osdi_preload.
.param vddv=3.3 vctrl=1.65
XL1 VDD OUTP 0 inductor w=8.22e-6 s=3.74e-6 d=141.975e-6 nr_r=4 m=1
XL2 VDD OUTN 0 inductor w=8.22e-6 s=3.74e-6 d=141.975e-6 nr_r=4 m=1
XC1 OUTP OUTN cap_cmim w=3.65e-6 l=3.65e-6 m=1
XCVP1 VCTRL OUTP VCTRL 0 sg13_hv_svaricap w=3.74e-6 l=0.3e-6 Nx=1
XCVP2 VCTRL OUTP VCTRL 0 sg13_hv_svaricap w=3.74e-6 l=0.3e-6 Nx=1
XCVP3 VCTRL OUTP VCTRL 0 sg13_hv_svaricap w=3.74e-6 l=0.3e-6 Nx=1
XCVP4 VCTRL OUTP VCTRL 0 sg13_hv_svaricap w=3.74e-6 l=0.3e-6 Nx=1
XCVP5 VCTRL OUTP VCTRL 0 sg13_hv_svaricap w=3.74e-6 l=0.3e-6 Nx=1
XCVP6 VCTRL OUTP VCTRL 0 sg13_hv_svaricap w=3.74e-6 l=0.3e-6 Nx=1
XCVP7 VCTRL OUTP VCTRL 0 sg13_hv_svaricap w=3.74e-6 l=0.3e-6 Nx=1
XCVP8 VCTRL OUTP VCTRL 0 sg13_hv_svaricap w=3.74e-6 l=0.3e-6 Nx=1
XCVP9 VCTRL OUTP VCTRL 0 sg13_hv_svaricap w=3.74e-6 l=0.3e-6 Nx=1
XCVP10 VCTRL OUTP VCTRL 0 sg13_hv_svaricap w=3.74e-6 l=0.3e-6 Nx=1
XCVP11 VCTRL OUTP VCTRL 0 sg13_hv_svaricap w=3.74e-6 l=0.3e-6 Nx=1
XCVP12 VCTRL OUTP VCTRL 0 sg13_hv_svaricap w=3.74e-6 l=0.3e-6 Nx=1
XCVP13 VCTRL OUTP VCTRL 0 sg13_hv_svaricap w=3.74e-6 l=0.3e-6 Nx=1
XCVP14 VCTRL OUTP VCTRL 0 sg13_hv_svaricap w=3.74e-6 l=0.3e-6 Nx=1
XCVP15 VCTRL OUTP VCTRL 0 sg13_hv_svaricap w=3.74e-6 l=0.3e-6 Nx=1
XCVP16 VCTRL OUTP VCTRL 0 sg13_hv_svaricap w=3.74e-6 l=0.3e-6 Nx=1
XCVN1 VCTRL OUTN VCTRL 0 sg13_hv_svaricap w=3.74e-6 l=0.3e-6 Nx=1
XCVN2 VCTRL OUTN VCTRL 0 sg13_hv_svaricap w=3.74e-6 l=0.3e-6 Nx=1
XCVN3 VCTRL OUTN VCTRL 0 sg13_hv_svaricap w=3.74e-6 l=0.3e-6 Nx=1
XCVN4 VCTRL OUTN VCTRL 0 sg13_hv_svaricap w=3.74e-6 l=0.3e-6 Nx=1
XCVN5 VCTRL OUTN VCTRL 0 sg13_hv_svaricap w=3.74e-6 l=0.3e-6 Nx=1
XCVN6 VCTRL OUTN VCTRL 0 sg13_hv_svaricap w=3.74e-6 l=0.3e-6 Nx=1
XCVN7 VCTRL OUTN VCTRL 0 sg13_hv_svaricap w=3.74e-6 l=0.3e-6 Nx=1
XCVN8 VCTRL OUTN VCTRL 0 sg13_hv_svaricap w=3.74e-6 l=0.3e-6 Nx=1
XCVN9 VCTRL OUTN VCTRL 0 sg13_hv_svaricap w=3.74e-6 l=0.3e-6 Nx=1
XCVN10 VCTRL OUTN VCTRL 0 sg13_hv_svaricap w=3.74e-6 l=0.3e-6 Nx=1
XCVN11 VCTRL OUTN VCTRL 0 sg13_hv_svaricap w=3.74e-6 l=0.3e-6 Nx=1
XCVN12 VCTRL OUTN VCTRL 0 sg13_hv_svaricap w=3.74e-6 l=0.3e-6 Nx=1
XCVN13 VCTRL OUTN VCTRL 0 sg13_hv_svaricap w=3.74e-6 l=0.3e-6 Nx=1
XCVN14 VCTRL OUTN VCTRL 0 sg13_hv_svaricap w=3.74e-6 l=0.3e-6 Nx=1
XCVN15 VCTRL OUTN VCTRL 0 sg13_hv_svaricap w=3.74e-6 l=0.3e-6 Nx=1
XCVN16 VCTRL OUTN VCTRL 0 sg13_hv_svaricap w=3.74e-6 l=0.3e-6 Nx=1
XQ1 OUTP OUTN TAIL 0 npn13G2v Nx=1 El=1.0
XQ2 OUTN OUTP TAIL 0 npn13G2v Nx=1 El=1.0
XQ3 TAIL NBIAS TE 0 npn13G2v Nx=1 El=2.0
RTE TE 0 2k m=1
RREF VDD NBIAS 20.5k m=1
XQ4 NBIAS NBIAS RE 0 npn13G2v Nx=1 El=1.0
RRE RE 0 4k m=1
VSUP VDD 0 dc {vddv}
.save i(vsup)
VCT VCTRL 0 dc {vctrl}
.ic v(OUTP)={vddv+0.005} v(OUTN)={vddv-0.005}
BD vd 0 V=v(outp)-v(outn)
.include sg13g2_inductor_em.spice
* The prescaler input on the tank (gate G1 load): same instance, bias and start-up .ic as sim/vco-prescaler-load.
.include ../../../design/netlist/prescaler.spice
IRF vdd iref dc 50u
VMC mc 0 dc 0
X1 outp outn mc iref pdp pdn vdd 0 prescaler
.ic v(x1.hp)=3.2 v(x1.hn)=3.0 v(x1.x2.mp)=3.0 v(x1.x2.mn)=3.2

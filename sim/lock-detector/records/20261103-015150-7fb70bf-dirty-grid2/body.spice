* sg13g2-lc-pll :: sim/lock-detector -- pinned PFD driving the pinned lock_detector at 50 MHz, VWIN held.
* Generated by scripts/ld_tool.py; do not edit. Circuit body: the model libraries, OSDI preloads, .tran and
* .meas cards are added by the runner (local) or by klt sim (C-grid).
.param vsup=3.3
.global sub!
VSUB sub! 0 0
VDD vdd 0 {vsup}
VREF ref 0 PULSE(0 {vsup} 20n 100p 100p 4.9n 20n)
VFB fb 0 PWL(0 0
+ 10000p 0 10100p {vsup} 15000p {vsup} 15100p 0
+ 30000p 0 30100p {vsup} 35000p {vsup} 35100p 0
+ 50000p 0 50100p {vsup} 55000p {vsup} 55100p 0
+ 72000p 0 72100p {vsup} 77000p {vsup} 77100p 0
+ 92000p 0 92100p {vsup} 97000p {vsup} 97100p 0
+ 112000p 0 112100p {vsup} 117000p {vsup} 117100p 0
+ 134000p 0 134100p {vsup} 139000p {vsup} 139100p 0
+ 154000p 0 154100p {vsup} 159000p {vsup} 159100p 0
+ 174000p 0 174100p {vsup} 179000p {vsup} 179100p 0
+ 196000p 0 196100p {vsup} 201000p {vsup} 201100p 0
+ 216000p 0 216100p {vsup} 221000p {vsup} 221100p 0
+ 236000p 0 236100p {vsup} 241000p {vsup} 241100p 0
+ 258000p 0 258100p {vsup} 263000p {vsup} 263100p 0
+ 278000p 0 278100p {vsup} 283000p {vsup} 283100p 0
+ 298000p 0 298100p {vsup} 303000p {vsup} 303100p 0
+ 320000p 0 320100p {vsup} 325000p {vsup} 325100p 0
+ 340000p 0 340100p {vsup} 345000p {vsup} 345100p 0
+ 360000p 0 360100p {vsup} 365000p {vsup} 365100p 0
+ 380500p 0 380600p {vsup} 385500p {vsup} 385600p 0
+ 400500p 0 400600p {vsup} 405500p {vsup} 405600p 0
+ 420500p 0 420600p {vsup} 425500p {vsup} 425600p 0
+ 441000p 0 441100p {vsup} 446000p {vsup} 446100p 0
+ 461000p 0 461100p {vsup} 466000p {vsup} 466100p 0
+ 481000p 0 481100p {vsup} 486000p {vsup} 486100p 0
+ 502000p 0 502100p {vsup} 507000p {vsup} 507100p 0
+ 522000p 0 522100p {vsup} 527000p {vsup} 527100p 0
+ 542000p 0 542100p {vsup} 547000p {vsup} 547100p 0
+ 563000p 0 563100p {vsup} 568000p {vsup} 568100p 0
+ 583000p 0 583100p {vsup} 588000p {vsup} 588100p 0
+ 603000p 0 603100p {vsup} 608000p {vsup} 608100p 0
+ 624000p 0 624100p {vsup} 629000p {vsup} 629100p 0
+ 644000p 0 644100p {vsup} 649000p {vsup} 649100p 0
+ 664000p 0 664100p {vsup} 669000p {vsup} 669100p 0
+ 685000p 0 685100p {vsup} 690000p {vsup} 690100p 0
+ 705000p 0 705100p {vsup} 710000p {vsup} 710100p 0
+ 725000p 0 725100p {vsup} 730000p {vsup} 730100p 0
+ 745500p 0 745600p {vsup} 750500p {vsup} 750600p 0
+ 765500p 0 765600p {vsup} 770500p {vsup} 770600p 0
+ 785500p 0 785600p {vsup} 790500p {vsup} 790600p 0
+ 806000p 0 806100p {vsup} 811000p {vsup} 811100p 0
+ 826000p 0 826100p {vsup} 831000p {vsup} 831100p 0
+ 846000p 0 846100p {vsup} 851000p {vsup} 851100p 0
+ 866500p 0 866600p {vsup} 871500p {vsup} 871600p 0
+ 886500p 0 886600p {vsup} 891500p {vsup} 891600p 0
+ 906500p 0 906600p {vsup} 911500p {vsup} 911600p 0
+ 927000p 0 927100p {vsup} 932000p {vsup} 932100p 0
+ 947000p 0 947100p {vsup} 952000p {vsup} 952100p 0
+ 967000p 0 967100p {vsup} 972000p {vsup} 972100p 0
+ 987500p 0 987600p {vsup} 992500p {vsup} 992600p 0
+ 1007500p 0 1007600p {vsup} 1012500p {vsup} 1012600p 0
+ 1027500p 0 1027600p {vsup} 1032500p {vsup} 1032600p 0
+ 1048000p 0 1048100p {vsup} 1053000p {vsup} 1053100p 0
+ 1068000p 0 1068100p {vsup} 1073000p {vsup} 1073100p 0
+ 1088000p 0 1088100p {vsup} 1093000p {vsup} 1093100p 0
+ 1109000p 0 1109100p {vsup} 1114000p {vsup} 1114100p 0
+ 1129000p 0 1129100p {vsup} 1134000p {vsup} 1134100p 0
+ 1149000p 0 1149100p {vsup} 1154000p {vsup} 1154100p 0
+ 1170000p 0 1170100p {vsup} 1175000p {vsup} 1175100p 0
+ 1190000p 0 1190100p {vsup} 1195000p {vsup} 1195100p 0
+ 1210000p 0 1210100p {vsup} 1215000p {vsup} 1215100p 0
+ 1230000p 0 1230100p {vsup} 1235000p {vsup} 1235100p 0
+ 1250000p 0 1250100p {vsup} 1255000p {vsup} 1255100p 0
+ 1270000p 0 1270100p {vsup} 1275000p {vsup} 1275100p 0
+ 1289000p 0 1289100p {vsup} 1294000p {vsup} 1294100p 0
+ 1309000p 0 1309100p {vsup} 1314000p {vsup} 1314100p 0
+ 1329000p 0 1329100p {vsup} 1334000p {vsup} 1334100p 0
+ 1348000p 0 1348100p {vsup} 1353000p {vsup} 1353100p 0
+ 1368000p 0 1368100p {vsup} 1373000p {vsup} 1373100p 0
+ 1388000p 0 1388100p {vsup} 1393000p {vsup} 1393100p 0
+ 1407500p 0 1407600p {vsup} 1412500p {vsup} 1412600p 0
+ 1427500p 0 1427600p {vsup} 1432500p {vsup} 1432600p 0
+ 1447500p 0 1447600p {vsup} 1452500p {vsup} 1452600p 0
+ 1467000p 0 1467100p {vsup} 1472000p {vsup} 1472100p 0
+ 1487000p 0 1487100p {vsup} 1492000p {vsup} 1492100p 0
+ 1507000p 0 1507100p {vsup} 1512000p {vsup} 1512100p 0
+ 1526500p 0 1526600p {vsup} 1531500p {vsup} 1531600p 0
+ 1546500p 0 1546600p {vsup} 1551500p {vsup} 1551600p 0
+ 1566500p 0 1566600p {vsup} 1571500p {vsup} 1571600p 0
+ 1586000p 0 1586100p {vsup} 1591000p {vsup} 1591100p 0
+ 1606000p 0 1606100p {vsup} 1611000p {vsup} 1611100p 0
+ 1626000p 0 1626100p {vsup} 1631000p {vsup} 1631100p 0
+ 1645500p 0 1645600p {vsup} 1650500p {vsup} 1650600p 0
+ 1665500p 0 1665600p {vsup} 1670500p {vsup} 1670600p 0
+ 1685500p 0 1685600p {vsup} 1690500p {vsup} 1690600p 0
+ 1705000p 0 1705100p {vsup} 1710000p {vsup} 1710100p 0
+ 1725000p 0 1725100p {vsup} 1730000p {vsup} 1730100p 0
+ 1745000p 0 1745100p {vsup} 1750000p {vsup} 1750100p 0
+ 1764000p 0 1764100p {vsup} 1769000p {vsup} 1769100p 0
+ 1784000p 0 1784100p {vsup} 1789000p {vsup} 1789100p 0
+ 1804000p 0 1804100p {vsup} 1809000p {vsup} 1809100p 0
+ 1823000p 0 1823100p {vsup} 1828000p {vsup} 1828100p 0
+ 1843000p 0 1843100p {vsup} 1848000p {vsup} 1848100p 0
+ 1863000p 0 1863100p {vsup} 1868000p {vsup} 1868100p 0
+ 1882000p 0 1882100p {vsup} 1887000p {vsup} 1887100p 0
+ 1902000p 0 1902100p {vsup} 1907000p {vsup} 1907100p 0
+ 1922000p 0 1922100p {vsup} 1927000p {vsup} 1927100p 0
+ 1941000p 0 1941100p {vsup} 1946000p {vsup} 1946100p 0
+ 1961000p 0 1961100p {vsup} 1966000p {vsup} 1966100p 0
+ 1981000p 0 1981100p {vsup} 1986000p {vsup} 1986100p 0
+ 2000500p 0 2000600p {vsup} 2005500p {vsup} 2005600p 0
+ 2020500p 0 2020600p {vsup} 2025500p {vsup} 2025600p 0
+ 2040500p 0 2040600p {vsup} 2045500p {vsup} 2045600p 0
+ 2060000p 0 2060100p {vsup} 2065000p {vsup} 2065100p 0
+ 2080000p 0 2080100p {vsup} 2085000p {vsup} 2085100p 0
+ 2100000p 0 2100100p {vsup} 2105000p {vsup} 2105100p 0
+ 2118000p 0 2118100p {vsup} 2123000p {vsup} 2123100p 0
+ 2138000p 0 2138100p {vsup} 2143000p {vsup} 2143100p 0
+ 2158000p 0 2158100p {vsup} 2163000p {vsup} 2163100p 0
+ 2176000p 0 2176100p {vsup} 2181000p {vsup} 2181100p 0
+ 2196000p 0 2196100p {vsup} 2201000p {vsup} 2201100p 0
+ 2216000p 0 2216100p {vsup} 2221000p {vsup} 2221100p 0
+ 2234000p 0 2234100p {vsup} 2239000p {vsup} 2239100p 0
+ 2254000p 0 2254100p {vsup} 2259000p {vsup} 2259100p 0
+ 2274000p 0 2274100p {vsup} 2279000p {vsup} 2279100p 0
+ 2292000p 0 2292100p {vsup} 2297000p {vsup} 2297100p 0
+ 2312000p 0 2312100p {vsup} 2317000p {vsup} 2317100p 0
+ 2332000p 0 2332100p {vsup} 2337000p {vsup} 2337100p 0
+ 2350000p 0 2350100p {vsup} 2355000p {vsup} 2355100p 0
+ 2370000p 0 2370100p {vsup} 2375000p {vsup} 2375100p 0
+ 2390000p 0 2390100p {vsup} 2395000p {vsup} 2395100p 0
+ 2410000p 0 2410100p {vsup} 2415000p {vsup} 2415100p 0
+ 2430000p 0 2430100p {vsup} 2435000p {vsup} 2435100p 0
+ 2450000p 0 2450100p {vsup} 2455000p {vsup} 2455100p 0
+ 2472000p 0 2472100p {vsup} 2477000p {vsup} 2477100p 0
+ 2492000p 0 2492100p {vsup} 2497000p {vsup} 2497100p 0
+ 2512000p 0 2512100p {vsup} 2517000p {vsup} 2517100p 0
+ 2534000p 0 2534100p {vsup} 2539000p {vsup} 2539100p 0
+ 2554000p 0 2554100p {vsup} 2559000p {vsup} 2559100p 0
+ 2574000p 0 2574100p {vsup} 2579000p {vsup} 2579100p 0
+ 2596000p 0 2596100p {vsup} 2601000p {vsup} 2601100p 0
+ 2616000p 0 2616100p {vsup} 2621000p {vsup} 2621100p 0
+ 2636000p 0 2636100p {vsup} 2641000p {vsup} 2641100p 0
+ 2658000p 0 2658100p {vsup} 2663000p {vsup} 2663100p 0
+ 2678000p 0 2678100p {vsup} 2683000p {vsup} 2683100p 0
+ 2698000p 0 2698100p {vsup} 2703000p {vsup} 2703100p 0
+ 2720000p 0 2720100p {vsup} 2725000p {vsup} 2725100p 0
+ 2740000p 0 2740100p {vsup} 2745000p {vsup} 2745100p 0
+ 2760000p 0 2760100p {vsup} 2765000p {vsup} 2765100p 0
+ 2780500p 0 2780600p {vsup} 2785500p {vsup} 2785600p 0
+ 2800500p 0 2800600p {vsup} 2805500p {vsup} 2805600p 0
+ 2820500p 0 2820600p {vsup} 2825500p {vsup} 2825600p 0
+ 2841000p 0 2841100p {vsup} 2846000p {vsup} 2846100p 0
+ 2861000p 0 2861100p {vsup} 2866000p {vsup} 2866100p 0
+ 2881000p 0 2881100p {vsup} 2886000p {vsup} 2886100p 0
+ 2902000p 0 2902100p {vsup} 2907000p {vsup} 2907100p 0
+ 2922000p 0 2922100p {vsup} 2927000p {vsup} 2927100p 0
+ 2942000p 0 2942100p {vsup} 2947000p {vsup} 2947100p 0
+ 2963000p 0 2963100p {vsup} 2968000p {vsup} 2968100p 0
+ 2983000p 0 2983100p {vsup} 2988000p {vsup} 2988100p 0
+ 3003000p 0 3003100p {vsup} 3008000p {vsup} 3008100p 0
+ 3024000p 0 3024100p {vsup} 3029000p {vsup} 3029100p 0
+ 3044000p 0 3044100p {vsup} 3049000p {vsup} 3049100p 0
+ 3064000p 0 3064100p {vsup} 3069000p {vsup} 3069100p 0
+ 3085000p 0 3085100p {vsup} 3090000p {vsup} 3090100p 0
+ 3105000p 0 3105100p {vsup} 3110000p {vsup} 3110100p 0
+ 3125000p 0 3125100p {vsup} 3130000p {vsup} 3130100p 0
+ 3145500p 0 3145600p {vsup} 3150500p {vsup} 3150600p 0
+ 3165500p 0 3165600p {vsup} 3170500p {vsup} 3170600p 0
+ 3185500p 0 3185600p {vsup} 3190500p {vsup} 3190600p 0
+ 3206000p 0 3206100p {vsup} 3211000p {vsup} 3211100p 0
+ 3226000p 0 3226100p {vsup} 3231000p {vsup} 3231100p 0
+ 3246000p 0 3246100p {vsup} 3251000p {vsup} 3251100p 0
+ 3266500p 0 3266600p {vsup} 3271500p {vsup} 3271600p 0
+ 3286500p 0 3286600p {vsup} 3291500p {vsup} 3291600p 0
+ 3306500p 0 3306600p {vsup} 3311500p {vsup} 3311600p 0
+ 3327000p 0 3327100p {vsup} 3332000p {vsup} 3332100p 0
+ 3347000p 0 3347100p {vsup} 3352000p {vsup} 3352100p 0
+ 3367000p 0 3367100p {vsup} 3372000p {vsup} 3372100p 0
+ 3387500p 0 3387600p {vsup} 3392500p {vsup} 3392600p 0
+ 3407500p 0 3407600p {vsup} 3412500p {vsup} 3412600p 0
+ 3427500p 0 3427600p {vsup} 3432500p {vsup} 3432600p 0
+ 3448000p 0 3448100p {vsup} 3453000p {vsup} 3453100p 0
+ 3468000p 0 3468100p {vsup} 3473000p {vsup} 3473100p 0
+ 3488000p 0 3488100p {vsup} 3493000p {vsup} 3493100p 0
+ 3509000p 0 3509100p {vsup} 3514000p {vsup} 3514100p 0
+ 3529000p 0 3529100p {vsup} 3534000p {vsup} 3534100p 0
+ 3549000p 0 3549100p {vsup} 3554000p {vsup} 3554100p 0
+ 3570000p 0 3570100p {vsup} 3575000p {vsup} 3575100p 0
+ 3590000p 0 3590100p {vsup} 3595000p {vsup} 3595100p 0
+ 3610000p 0 3610100p {vsup} 3615000p {vsup} 3615100p 0
+ 3630000p 0 3630100p {vsup} 3635000p {vsup} 3635100p 0
+ 3650000p 0 3650100p {vsup} 3655000p {vsup} 3655100p 0
+ 3670000p 0 3670100p {vsup} 3675000p {vsup} 3675100p 0
+ 3689000p 0 3689100p {vsup} 3694000p {vsup} 3694100p 0
+ 3709000p 0 3709100p {vsup} 3714000p {vsup} 3714100p 0
+ 3729000p 0 3729100p {vsup} 3734000p {vsup} 3734100p 0
+ 3748000p 0 3748100p {vsup} 3753000p {vsup} 3753100p 0
+ 3768000p 0 3768100p {vsup} 3773000p {vsup} 3773100p 0
+ 3788000p 0 3788100p {vsup} 3793000p {vsup} 3793100p 0
+ 3807500p 0 3807600p {vsup} 3812500p {vsup} 3812600p 0
+ 3827500p 0 3827600p {vsup} 3832500p {vsup} 3832600p 0
+ 3847500p 0 3847600p {vsup} 3852500p {vsup} 3852600p 0
+ 3867000p 0 3867100p {vsup} 3872000p {vsup} 3872100p 0
+ 3887000p 0 3887100p {vsup} 3892000p {vsup} 3892100p 0
+ 3907000p 0 3907100p {vsup} 3912000p {vsup} 3912100p 0
+ 3926500p 0 3926600p {vsup} 3931500p {vsup} 3931600p 0
+ 3946500p 0 3946600p {vsup} 3951500p {vsup} 3951600p 0
+ 3966500p 0 3966600p {vsup} 3971500p {vsup} 3971600p 0
+ 3986000p 0 3986100p {vsup} 3991000p {vsup} 3991100p 0
+ 4006000p 0 4006100p {vsup} 4011000p {vsup} 4011100p 0
+ 4026000p 0 4026100p {vsup} 4031000p {vsup} 4031100p 0
+ 4045500p 0 4045600p {vsup} 4050500p {vsup} 4050600p 0
+ 4065500p 0 4065600p {vsup} 4070500p {vsup} 4070600p 0
+ 4085500p 0 4085600p {vsup} 4090500p {vsup} 4090600p 0
+ 4105000p 0 4105100p {vsup} 4110000p {vsup} 4110100p 0
+ 4125000p 0 4125100p {vsup} 4130000p {vsup} 4130100p 0
+ 4145000p 0 4145100p {vsup} 4150000p {vsup} 4150100p 0
+ 4164000p 0 4164100p {vsup} 4169000p {vsup} 4169100p 0
+ 4184000p 0 4184100p {vsup} 4189000p {vsup} 4189100p 0
+ 4204000p 0 4204100p {vsup} 4209000p {vsup} 4209100p 0
+ 4223000p 0 4223100p {vsup} 4228000p {vsup} 4228100p 0
+ 4243000p 0 4243100p {vsup} 4248000p {vsup} 4248100p 0
+ 4263000p 0 4263100p {vsup} 4268000p {vsup} 4268100p 0
+ 4282000p 0 4282100p {vsup} 4287000p {vsup} 4287100p 0
+ 4302000p 0 4302100p {vsup} 4307000p {vsup} 4307100p 0
+ 4322000p 0 4322100p {vsup} 4327000p {vsup} 4327100p 0
+ 4341000p 0 4341100p {vsup} 4346000p {vsup} 4346100p 0
+ 4361000p 0 4361100p {vsup} 4366000p {vsup} 4366100p 0
+ 4381000p 0 4381100p {vsup} 4386000p {vsup} 4386100p 0
+ 4400500p 0 4400600p {vsup} 4405500p {vsup} 4405600p 0
+ 4420500p 0 4420600p {vsup} 4425500p {vsup} 4425600p 0
+ 4440500p 0 4440600p {vsup} 4445500p {vsup} 4445600p 0
+ 4460000p 0 4460100p {vsup} 4465000p {vsup} 4465100p 0
+ 4480000p 0 4480100p {vsup} 4485000p {vsup} 4485100p 0
+ 4500000p 0 4500100p {vsup} 4505000p {vsup} 4505100p 0
+ 4518000p 0 4518100p {vsup} 4523000p {vsup} 4523100p 0
+ 4538000p 0 4538100p {vsup} 4543000p {vsup} 4543100p 0
+ 4558000p 0 4558100p {vsup} 4563000p {vsup} 4563100p 0
+ 4576000p 0 4576100p {vsup} 4581000p {vsup} 4581100p 0
+ 4596000p 0 4596100p {vsup} 4601000p {vsup} 4601100p 0
+ 4616000p 0 4616100p {vsup} 4621000p {vsup} 4621100p 0
+ 4634000p 0 4634100p {vsup} 4639000p {vsup} 4639100p 0
+ 4654000p 0 4654100p {vsup} 4659000p {vsup} 4659100p 0
+ 4674000p 0 4674100p {vsup} 4679000p {vsup} 4679100p 0
+ 4692000p 0 4692100p {vsup} 4697000p {vsup} 4697100p 0
+ 4712000p 0 4712100p {vsup} 4717000p {vsup} 4717100p 0
+ 4732000p 0 4732100p {vsup} 4737000p {vsup} 4737100p 0
+ 4750000p 0 4750100p {vsup} 4755000p {vsup} 4755100p 0
+ 4770000p 0 4770100p {vsup} 4775000p {vsup} 4775100p 0
+ 4790000p 0 4790100p {vsup} 4795000p {vsup} 4795100p 0
+ 4810000p 0 4810100p {vsup} 4815000p {vsup} 4815100p 0
+ 4830000p 0 4830100p {vsup} 4835000p {vsup} 4835100p 0
+ 4850000p 0 4850100p {vsup} 4855000p {vsup} 4855100p 0
+ 4872000p 0 4872100p {vsup} 4877000p {vsup} 4877100p 0
+ 4892000p 0 4892100p {vsup} 4897000p {vsup} 4897100p 0
+ 4912000p 0 4912100p {vsup} 4917000p {vsup} 4917100p 0
+ 4934000p 0 4934100p {vsup} 4939000p {vsup} 4939100p 0
+ 4954000p 0 4954100p {vsup} 4959000p {vsup} 4959100p 0
+ 4974000p 0 4974100p {vsup} 4979000p {vsup} 4979100p 0
+ 4996000p 0 4996100p {vsup} 5001000p {vsup} 5001100p 0
+ 5016000p 0 5016100p {vsup} 5021000p {vsup} 5021100p 0
+ 5036000p 0 5036100p {vsup} 5041000p {vsup} 5041100p 0
+ 5058000p 0 5058100p {vsup} 5063000p {vsup} 5063100p 0
+ 5078000p 0 5078100p {vsup} 5083000p {vsup} 5083100p 0
+ 5098000p 0 5098100p {vsup} 5103000p {vsup} 5103100p 0
+ 5120000p 0 5120100p {vsup} 5125000p {vsup} 5125100p 0
+ 5140000p 0 5140100p {vsup} 5145000p {vsup} 5145100p 0
+ 5160000p 0 5160100p {vsup} 5165000p {vsup} 5165100p 0
+ 5180500p 0 5180600p {vsup} 5185500p {vsup} 5185600p 0
+ 5200500p 0 5200600p {vsup} 5205500p {vsup} 5205600p 0
+ 5220500p 0 5220600p {vsup} 5225500p {vsup} 5225600p 0
+ 5241000p 0 5241100p {vsup} 5246000p {vsup} 5246100p 0
+ 5261000p 0 5261100p {vsup} 5266000p {vsup} 5266100p 0
+ 5281000p 0 5281100p {vsup} 5286000p {vsup} 5286100p 0
+ 5302000p 0 5302100p {vsup} 5307000p {vsup} 5307100p 0
+ 5322000p 0 5322100p {vsup} 5327000p {vsup} 5327100p 0
+ 5342000p 0 5342100p {vsup} 5347000p {vsup} 5347100p 0
+ 5363000p 0 5363100p {vsup} 5368000p {vsup} 5368100p 0
+ 5383000p 0 5383100p {vsup} 5388000p {vsup} 5388100p 0
+ 5403000p 0 5403100p {vsup} 5408000p {vsup} 5408100p 0
+ 5424000p 0 5424100p {vsup} 5429000p {vsup} 5429100p 0
+ 5444000p 0 5444100p {vsup} 5449000p {vsup} 5449100p 0
+ 5464000p 0 5464100p {vsup} 5469000p {vsup} 5469100p 0
+ 5485000p 0 5485100p {vsup} 5490000p {vsup} 5490100p 0
+ 5505000p 0 5505100p {vsup} 5510000p {vsup} 5510100p 0
+ 5525000p 0 5525100p {vsup} 5530000p {vsup} 5530100p 0
+ 5545500p 0 5545600p {vsup} 5550500p {vsup} 5550600p 0
+ 5565500p 0 5565600p {vsup} 5570500p {vsup} 5570600p 0
+ 5585500p 0 5585600p {vsup} 5590500p {vsup} 5590600p 0
+ 5606000p 0 5606100p {vsup} 5611000p {vsup} 5611100p 0
+ 5626000p 0 5626100p {vsup} 5631000p {vsup} 5631100p 0
+ 5646000p 0 5646100p {vsup} 5651000p {vsup} 5651100p 0
+ 5666500p 0 5666600p {vsup} 5671500p {vsup} 5671600p 0
+ 5686500p 0 5686600p {vsup} 5691500p {vsup} 5691600p 0
+ 5706500p 0 5706600p {vsup} 5711500p {vsup} 5711600p 0
+ 5727000p 0 5727100p {vsup} 5732000p {vsup} 5732100p 0
+ 5747000p 0 5747100p {vsup} 5752000p {vsup} 5752100p 0
+ 5767000p 0 5767100p {vsup} 5772000p {vsup} 5772100p 0
+ 5787500p 0 5787600p {vsup} 5792500p {vsup} 5792600p 0
+ 5807500p 0 5807600p {vsup} 5812500p {vsup} 5812600p 0
+ 5827500p 0 5827600p {vsup} 5832500p {vsup} 5832600p 0
+ 5848000p 0 5848100p {vsup} 5853000p {vsup} 5853100p 0
+ 5868000p 0 5868100p {vsup} 5873000p {vsup} 5873100p 0
+ 5888000p 0 5888100p {vsup} 5893000p {vsup} 5893100p 0
+ 5909000p 0 5909100p {vsup} 5914000p {vsup} 5914100p 0
+ 5929000p 0 5929100p {vsup} 5934000p {vsup} 5934100p 0
+ 5949000p 0 5949100p {vsup} 5954000p {vsup} 5954100p 0
+ 5970000p 0 5970100p {vsup} 5975000p {vsup} 5975100p 0
+ 5990000p 0 5990100p {vsup} 5995000p {vsup} 5995100p 0
+ 6010000p 0 6010100p {vsup} 6015000p {vsup} 6015100p 0
+ 6020000p 0 6020100p {vsup} 6025000p {vsup} 6025100p 0
+ 6040000p 0 6040100p {vsup} 6045000p {vsup} 6045100p 0
+ 6060000p 0 6060100p {vsup} 6065000p {vsup} 6065100p 0
+ 6080000p 0 6080100p {vsup} 6085000p {vsup} 6085100p 0
+ 6100000p 0 6100100p {vsup} 6105000p {vsup} 6105100p 0
+ 6120000p 0 6120100p {vsup} 6125000p {vsup} 6125100p 0
+ 6140000p 0 6140100p {vsup} 6145000p {vsup} 6145100p 0
+ 6160000p 0 6160100p {vsup} 6165000p {vsup} 6165100p 0
+ 6180000p 0 6180100p {vsup} 6185000p {vsup} 6185100p 0
+ 6200000p 0 6200100p {vsup} 6205000p {vsup} 6205100p 0
+ 6220000p 0 6220100p {vsup} 6225000p {vsup} 6225100p 0
+ 6240000p 0 6240100p {vsup} 6245000p {vsup} 6245100p 0
+ 6260000p 0 6260100p {vsup} 6265000p {vsup} 6265100p 0
+ 6280000p 0 6280100p {vsup} 6285000p {vsup} 6285100p 0
+ 6300000p 0 6300100p {vsup} 6305000p {vsup} 6305100p 0
+ 6320000p 0 6320100p {vsup} 6325000p {vsup} 6325100p 0
+ 6340000p 0 6340100p {vsup} 6345000p {vsup} 6345100p 0
+ 6360000p 0 6360100p {vsup} 6365000p {vsup} 6365100p 0
+ 6380000p 0 6380100p {vsup} 6385000p {vsup} 6385100p 0
+ 6400000p 0 6400100p {vsup} 6405000p {vsup} 6405100p 0
+ 6420000p 0 6420100p {vsup} 6425000p {vsup} 6425100p 0
+ 6440000p 0 6440100p {vsup} 6445000p {vsup} 6445100p 0
+ 6460000p 0 6460100p {vsup} 6465000p {vsup} 6465100p 0
+ 6480000p 0 6480100p {vsup} 6485000p {vsup} 6485100p 0
+ 6500000p 0 6500100p {vsup} 6505000p {vsup} 6505100p 0
+ 6520000p 0 6520100p {vsup} 6525000p {vsup} 6525100p 0
+ 6540000p 0 6540100p {vsup} 6545000p {vsup} 6545100p 0
+ 6560000p 0 6560100p {vsup} 6565000p {vsup} 6565100p 0
+ 6580000p 0 6580100p {vsup} 6585000p {vsup} 6585100p 0
+ 6600000p 0 6600100p {vsup} 6605000p {vsup} 6605100p 0
+ 6620000p 0 6620100p {vsup} 6625000p {vsup} 6625100p 0
+ 6640000p 0 6640100p {vsup} 6645000p {vsup} 6645100p 0
+ 6660000p 0 6660100p {vsup} 6665000p {vsup} 6665100p 0
+ 6680000p 0 6680100p {vsup} 6685000p {vsup} 6685100p 0
+ 6700000p 0 6700100p {vsup} 6705000p {vsup} 6705100p 0
+ 6720000p 0 6720100p {vsup} 6725000p {vsup} 6725100p 0
+ 6740000p 0 6740100p {vsup} 6745000p {vsup} 6745100p 0
+ 6760000p 0 6760100p {vsup} 6765000p {vsup} 6765100p 0
+ 6780000p 0 6780100p {vsup} 6785000p {vsup} 6785100p 0
+ 6800000p 0 6800100p {vsup} 6805000p {vsup} 6805100p 0
+ 6820000p 0 6820100p {vsup} 6825000p {vsup} 6825100p 0
+ 6840000p 0 6840100p {vsup} 6845000p {vsup} 6845100p 0
+ 6860000p 0 6860100p {vsup} 6865000p {vsup} 6865100p 0
+ 6880000p 0 6880100p {vsup} 6885000p {vsup} 6885100p 0
+ 6900000p 0 6900100p {vsup} 6905000p {vsup} 6905100p 0
+ 6920000p 0 6920100p {vsup} 6925000p {vsup} 6925100p 0
+ )
VH xld.vwin 0 PWL(0 1
+ 1220000p 1.0 1220200p 1.5
+ 2420000p 1.5 2420200p 2.0
+ 3620000p 2.0 3620200p 2.5
+ 4820000p 2.5 4820200p 3.0
+ 6020000p 3.0 6021000p 3.3
+ 6060000p 3.3 6460000p 0 6500000p 0 6900000p 3.3 6940000p 3.3)
.include ../../../../.fetched/sg13g2-pll/design/netlist/pfd.spice
.include ../../../../.fetched/sg13g2-pll/design/netlist/lock_detector.spice
XPFD ref fb up dn vdd 0 pfd
XLD up dn lock vdd 0 lock_detector
.options reltol=1e-3 abstol=1e-10 vntol=1e-5 chgtol=1e-14

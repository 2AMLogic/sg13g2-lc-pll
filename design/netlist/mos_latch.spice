* sg13g2-lc-pll :: mos_latch -- generated by design/netlist.sh (klt netlist) from design/mos_latch.sch
* do not edit by hand.
** sch_path: design/mos_latch.sch
.subckt mos_latch D DB CK CKB IB Q QB VDD VSS
*.ipin D
*.ipin DB
*.ipin CK
*.ipin CKB
*.ipin IB
*.opin Q
*.opin QB
*.iopin VDD
*.iopin VSS
RL1 VDD Q 2400 m=1
RL2 VDD QB 2400 m=1
XMT1 QB D e1 VSS sg13_hv_nmos w=12u l=0.45u ng=1 m=1
XMT2 Q DB e1 VSS sg13_hv_nmos w=12u l=0.45u ng=1 m=1
XMH1 QB Q e2 VSS sg13_hv_nmos w=12u l=0.45u ng=1 m=1
XMH2 Q QB e2 VSS sg13_hv_nmos w=12u l=0.45u ng=1 m=1
XMC1 e1 CK t VSS sg13_hv_nmos w=12u l=0.45u ng=1 m=1
XMC2 e2 CKB t VSS sg13_hv_nmos w=12u l=0.45u ng=1 m=1
XMTL t IB VSS VSS sg13_hv_nmos w=12u l=0.45u ng=1 m=2
.ends

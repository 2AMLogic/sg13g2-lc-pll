* sg13g2-lc-pll :: prescaler -- generated by design/netlist.sh (klt netlist) from design/prescaler.sch
* do not edit by hand.
** sch_path: design/prescaler.sch
.subckt prescaler INP INN MC IREF OUTP OUTN VDD VSS
*.ipin INP
*.ipin INN
*.ipin MC
*.ipin IREF
*.opin OUTP
*.opin OUTN
*.iopin VDD
*.iopin VSS
XQREF IREF IREF reref VSS npn13G2v Nx=1 El=1
XRREF reref VSS VSS rppd w=1u l=9.05u m=1 b=0
X89 INP INN MC IREF OUTP OUTN VDD VSS div89_dm
.ends

* expanding   symbol:  div89_dm.sym # of pins=8
** sym_path: design/div89_dm.sym
** sch_path: design/div89_dm.sch
.subckt div89_dm INP INN MC IB OUTP OUTN VDD VSS
*.ipin INP
*.ipin INN
*.ipin MC
*.ipin IB
*.opin OUTP
*.opin OUTN
*.iopin VDD
*.iopin VSS
XMC MC IB MCP MCN VDD VSS mc_conv
XMCL MCP MCN IB MCL MCLB VDD VSS cml_ef
XES S1 S1B IB S1L S1LB VDD VSS cml_ef
XG1 OUTP OUTN S1L S1LB IB G GB VDD VSS cml_and2
XGM G GB MCL MCLB IB M MB VDD VSS cml_and2
XC23 INP INN M MB IB C1 C1B VDD VSS cml_div23
XS1 C1 C1B IB S1 S1B VDD VSS div2_cml_ls
XS2 S1 S1B IB OUTP OUTN VDD VSS div2_cml_ls
.ends

* expanding   symbol:  mc_conv.sym # of pins=6
** sym_path: design/mc_conv.sym
** sch_path: design/mc_conv.sch
.subckt mc_conv MC IB MCP MCN VDD VSS
*.ipin MC
*.ipin IB
*.opin MCP
*.opin MCN
*.iopin VDD
*.iopin VSS
XRIN MC bm VSS rppd w=1u l=77.7u m=1 b=0
XRD1 VDD vr VSS rppd w=1u l=46.4u m=1 b=0
XRD2 vr VSS VSS rppd w=1u l=108.8u m=1 b=0
XRL1 VDD MCP VSS rppd w=1u l=9.05u m=1 b=0
XRL2 VDD MCN VSS rppd w=1u l=9.05u m=1 b=0
XQM1 MCN bm t VSS npn13G2v Nx=1 El=1
XQM2 MCP vr t VSS npn13G2v Nx=1 El=1
XQT t IB teT VSS npn13G2v Nx=2 El=1
XRT teT VSS VSS rppd w=2u l=9.05u m=1 b=0
.ends

* expanding   symbol:  cml_ef.sym # of pins=7
** sym_path: design/cml_ef.sym
** sch_path: design/cml_ef.sch
.subckt cml_ef IN INB IB OUT OUTB VDD VSS
*.ipin IN
*.ipin INB
*.ipin IB
*.opin OUT
*.opin OUTB
*.iopin VDD
*.iopin VSS
XQE1 VDD IN OUT VSS npn13G2v Nx=1 El=1
XQE2 VDD INB OUTB VSS npn13G2v Nx=1 El=1
XQF1 qc1 IB f1 VSS npn13G2v Nx=1 El=1
XRF1 f1 VSS VSS rppd w=1u l=9.05u m=1 b=0
XQF2 qc2 IB f2 VSS npn13G2v Nx=1 El=1
XRF2 f2 VSS VSS rppd w=1u l=9.05u m=1 b=0
XDF1 OUT OUT d1 VSS npn13G2v Nx=1 El=1
XDF2 OUTB OUTB d2 VSS npn13G2v Nx=1 El=1
XRDF1 d1 qc1 VSS rppd w=1u l=15.3u m=1 b=0
XRDF2 d2 qc2 VSS rppd w=1u l=15.3u m=1 b=0
.ends

* expanding   symbol:  cml_and2.sym # of pins=9
** sym_path: design/cml_and2.sym
** sch_path: design/cml_and2.sch
.subckt cml_and2 A AB B BB IB Q QB VDD VSS
*.ipin A
*.ipin AB
*.ipin B
*.ipin BB
*.ipin IB
*.opin Q
*.opin QB
*.iopin VDD
*.iopin VSS
XRL1 VDD Q VSS rppd w=1u l=9.05u m=1 b=0
XRL2 VDD QB VSS rppd w=1u l=9.05u m=1 b=0
XQA1 QB A n1 VSS npn13G2v Nx=1 El=1
XQA2 Q AB n1 VSS npn13G2v Nx=1 El=1
XQB1 n1 B t VSS npn13G2v Nx=1 El=1
XQB2 Q BB t VSS npn13G2v Nx=1 El=1
XQT tc IB teT VSS npn13G2v Nx=2 El=1
XRT teT VSS VSS rppd w=2u l=9.05u m=1 b=0
XRTC t tc VSS rppd w=1u l=9.05u m=1 b=0
.ends

* expanding   symbol:  cml_div23.sym # of pins=9
** sym_path: design/cml_div23.sym
** sch_path: design/cml_div23.sch
.subckt cml_div23 INP INN M MB IB Q1 Q1B VDD VSS
*.ipin INP
*.ipin INN
*.ipin M
*.ipin MB
*.ipin IB
*.opin Q1
*.opin Q1B
*.iopin VDD
*.iopin VSS
XCK INP INN IB CKP CKN VDD VSS cml_ef
XQ1L Q1 Q1B IB Q1L Q1LB VDD VSS cml_ef
XG1 Q2B Q2 Q1LB Q1L IB D1 D1B VDD VSS cml_and2
XG2 M MB Q1L Q1LB IB D2 D2B VDD VSS cml_and2
XF1 D1 D1B CKP CKN IB Q1 Q1B VDD VSS cml_dff
XF2 D2 D2B CKP CKN IB Q2 Q2B VDD VSS cml_dff
.ends

* expanding   symbol:  div2_cml_ls.sym # of pins=7
** sym_path: design/div2_cml_ls.sym
** sch_path: design/div2_cml_ls.sch
.subckt div2_cml_ls INP INN IB QP QN VDD VSS
*.ipin INP
*.ipin INN
*.ipin IB
*.opin QP
*.opin QN
*.iopin VDD
*.iopin VSS
XEF INP INN IB CKP CKN VDD VSS cml_ef
XM QN QP CKP CKN IB MP MN VDD VSS cml_latch
XS MP MN CKN CKP IB QP QN VDD VSS cml_latch
.ends

* expanding   symbol:  cml_dff.sym # of pins=9
** sym_path: design/cml_dff.sym
** sch_path: design/cml_dff.sch
.subckt cml_dff D DB CK CKB IB Q QB VDD VSS
*.ipin D
*.ipin DB
*.ipin CK
*.ipin CKB
*.ipin IB
*.opin Q
*.opin QB
*.iopin VDD
*.iopin VSS
XM D DB CK CKB IB M MB VDD VSS cml_dff_latch
XS M MB CKB CK IB Q QB VDD VSS cml_dff_latch
.ends

* expanding   symbol:  cml_latch.sym # of pins=9
** sym_path: design/cml_latch.sym
** sch_path: design/cml_latch.sch
.subckt cml_latch D DB CK CKB IB Q QB VDD VSS
*.ipin D
*.ipin DB
*.ipin CK
*.ipin CKB
*.ipin IB
*.opin Q
*.opin QB
*.iopin VDD
*.iopin VSS
XRL1 VDD Q VSS rppd w=1u l=9.05u m=1 b=0
XRL2 VDD QB VSS rppd w=1u l=9.05u m=1 b=0
XQT1 QB D e1 VSS npn13G2v Nx=1 El=1
XQT2 Q DB e1 VSS npn13G2v Nx=1 El=1
XQH1 QB Q e2 VSS npn13G2v Nx=1 El=1
XQH2 Q QB e2 VSS npn13G2v Nx=1 El=1
XQC1 e1 CK t VSS npn13G2v Nx=1 El=1
XQC2 e2 CKB t VSS npn13G2v Nx=1 El=1
XQT tc IB teT VSS npn13G2v Nx=2 El=1
XRT teT VSS VSS rppd w=2u l=9.05u m=1 b=0
XRTC t tc VSS rppd w=1u l=9.05u m=1 b=0
.ends

* expanding   symbol:  cml_dff_latch.sym # of pins=9
** sym_path: design/cml_dff_latch.sym
** sch_path: design/cml_dff_latch.sch
.subckt cml_dff_latch D DB CK CKB IB Q QB VDD VSS
*.ipin D
*.ipin DB
*.ipin CK
*.ipin CKB
*.ipin IB
*.opin Q
*.opin QB
*.iopin VDD
*.iopin VSS
XRL1 VDD Q VSS rppd w=1u l=7.8u m=1 b=0
XRL2 VDD QB VSS rppd w=1u l=7.8u m=1 b=0
XQT1 QB D e1 VSS npn13G2v Nx=1 El=1
XQT2 Q DB e1 VSS npn13G2v Nx=1 El=1
XQH1 QB Q e2 VSS npn13G2v Nx=1 El=1
XQH2 Q QB e2 VSS npn13G2v Nx=1 El=1
XQC1 e1 CK t VSS npn13G2v Nx=1 El=1
XQC2 e2 CKB t VSS npn13G2v Nx=1 El=1
XQT tc IB teT VSS npn13G2v Nx=2 El=1
XRT teT VSS VSS rppd w=2u l=9.05u m=1 b=0
XRTC t tc VSS rppd w=1u l=9.05u m=1 b=0
.ends

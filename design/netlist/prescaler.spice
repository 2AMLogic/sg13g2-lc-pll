* sg13g2-lc-pll :: prescaler -- generated by design/netlist.sh (klt netlist) from design/prescaler.sch
* do not edit by hand.
** sch_path: design/prescaler.sch
.subckt prescaler INP INN MC IREF OUTP OUTN VDD VSS
*.ipin INP
*.ipin INN
*.ipin MC
*.ipin IREF
*.opin OUTP
*.opin OUTN
*.iopin VDD
*.iopin VSS
XQREF IREF IREF reref VSS npn13G2v Nx=1 El=1
RREF reref VSS 2400 m=1
X2 INP INN IREF HP HN VDD VSS div2_cml
X45 HP HN MC IREF OUTP OUTN VDD VSS div45_dm
.ends

* expanding   symbol:  div2_cml.sym # of pins=7
** sym_path: design/div2_cml.sym
** sch_path: design/div2_cml.sch
.subckt div2_cml INP INN IB QP QN VDD VSS
*.ipin INP
*.ipin INN
*.ipin IB
*.opin QP
*.opin QN
*.iopin VDD
*.iopin VSS
XEF INP INN IB CKP CKN VDD VSS div2_ef_hs
XM QN QP CKP CKN IB MP MN VDD VSS div2_latch_hs
XS MP MN CKN CKP IB QP QN VDD VSS div2_latch_hs
.ends

* expanding   symbol:  div45_dm.sym # of pins=8
** sym_path: design/div45_dm.sym
** sch_path: design/div45_dm.sch
.subckt div45_dm INP INN MC IB OUTP OUTN VDD VSS
*.ipin INP
*.ipin INN
*.ipin MC
*.ipin IB
*.opin OUTP
*.opin OUTN
*.iopin VDD
*.iopin VSS
XMC MC IB MCP MCN VDD VSS mc_conv
XMCL MCP MCN IB MCL MCLB VDD VSS cml_ef
XGM OUTP OUTN MCL MCLB IB M MB VDD VSS cml_and2
XC23 INP INN M MB IB C1 C1B VDD VSS cml_div23
XT C1 C1B IB OUTP OUTN VDD VSS div2_cml_ls
.ends

* expanding   symbol:  div2_ef_hs.sym # of pins=7
** sym_path: design/div2_ef_hs.sym
** sch_path: design/div2_ef_hs.sch
.subckt div2_ef_hs IN INB IB OUT OUTB VDD VSS
*.ipin IN
*.ipin INB
*.ipin IB
*.opin OUT
*.opin OUTB
*.iopin VDD
*.iopin VSS
XQE1 VDD IN OUT VSS npn13G2v Nx=1 El=1
XQE2 VDD INB OUTB VSS npn13G2v Nx=1 El=1
XQF1 OUT IB f1 VSS npn13G2v Nx=1 El=1
RF1 f1 VSS 2400 m=1
XQF2 OUTB IB f2 VSS npn13G2v Nx=1 El=1
RF2 f2 VSS 2400 m=1
.ends

* expanding   symbol:  div2_latch_hs.sym # of pins=9
** sym_path: design/div2_latch_hs.sym
** sch_path: design/div2_latch_hs.sch
.subckt div2_latch_hs D DB CK CKB IB Q QB VDD VSS
*.ipin D
*.ipin DB
*.ipin CK
*.ipin CKB
*.ipin IB
*.opin Q
*.opin QB
*.iopin VDD
*.iopin VSS
RL1 VDD Q 1500 m=1
RL2 VDD QB 1500 m=1
XQT1 QB D e1 VSS npn13G2v Nx=1 El=1
XQT2 Q DB e1 VSS npn13G2v Nx=1 El=1
XQH1 QB Q e2 VSS npn13G2v Nx=1 El=1
XQH2 Q QB e2 VSS npn13G2v Nx=1 El=1
XQC1 e1 CK t VSS npn13G2v Nx=1 El=1
XQC2 e2 CKB t VSS npn13G2v Nx=1 El=1
XQT t IB teT VSS npn13G2v Nx=4 El=1
RT teT VSS 600 m=1
.ends

* expanding   symbol:  mc_conv.sym # of pins=6
** sym_path: design/mc_conv.sym
** sch_path: design/mc_conv.sch
.subckt mc_conv MC IB MCP MCN VDD VSS
*.ipin MC
*.ipin IB
*.opin MCP
*.opin MCN
*.iopin VDD
*.iopin VSS
RIN MC bm 20k m=1
RD1 VDD vr 20k m=1
RD2 vr VSS 20k m=1
RL1 VDD MCP 2400 m=1
RL2 VDD MCN 2400 m=1
XQM1 MCN bm t VSS npn13G2v Nx=1 El=1
XQM2 MCP vr t VSS npn13G2v Nx=1 El=1
XQT t IB teT VSS npn13G2v Nx=2 El=1
RT teT VSS 1200 m=1
.ends

* expanding   symbol:  cml_ef.sym # of pins=7
** sym_path: design/cml_ef.sym
** sch_path: design/cml_ef.sch
.subckt cml_ef IN INB IB OUT OUTB VDD VSS
*.ipin IN
*.ipin INB
*.ipin IB
*.opin OUT
*.opin OUTB
*.iopin VDD
*.iopin VSS
XQE1 VDD IN OUT VSS npn13G2v Nx=1 El=1
XQE2 VDD INB OUTB VSS npn13G2v Nx=1 El=1
XQF1 OUT IB f1 VSS npn13G2v Nx=1 El=1
RF1 f1 VSS 2400 m=1
XQF2 OUTB IB f2 VSS npn13G2v Nx=1 El=1
RF2 f2 VSS 2400 m=1
.ends

* expanding   symbol:  cml_and2.sym # of pins=9
** sym_path: design/cml_and2.sym
** sch_path: design/cml_and2.sch
.subckt cml_and2 A AB B BB IB Q QB VDD VSS
*.ipin A
*.ipin AB
*.ipin B
*.ipin BB
*.ipin IB
*.opin Q
*.opin QB
*.iopin VDD
*.iopin VSS
RL1 VDD Q 2400 m=1
RL2 VDD QB 2400 m=1
XQA1 QB A n1 VSS npn13G2v Nx=1 El=1
XQA2 Q AB n1 VSS npn13G2v Nx=1 El=1
XQB1 n1 B t VSS npn13G2v Nx=1 El=1
XQB2 Q BB t VSS npn13G2v Nx=1 El=1
XQT t IB teT VSS npn13G2v Nx=2 El=1
RT teT VSS 1200 m=1
.ends

* expanding   symbol:  cml_div23.sym # of pins=9
** sym_path: design/cml_div23.sym
** sch_path: design/cml_div23.sch
.subckt cml_div23 INP INN M MB IB Q1 Q1B VDD VSS
*.ipin INP
*.ipin INN
*.ipin M
*.ipin MB
*.ipin IB
*.opin Q1
*.opin Q1B
*.iopin VDD
*.iopin VSS
XCK INP INN IB CKP CKN VDD VSS cml_ef
XQ1L Q1 Q1B IB Q1L Q1LB VDD VSS cml_ef
XG1 Q2B Q2 Q1LB Q1L IB D1 D1B VDD VSS cml_and2
XG2 M MB Q1L Q1LB IB D2 D2B VDD VSS cml_and2
XF1 D1 D1B CKP CKN IB Q1 Q1B VDD VSS cml_dff
XF2 D2 D2B CKP CKN IB Q2 Q2B VDD VSS cml_dff
.ends

* expanding   symbol:  div2_cml_ls.sym # of pins=7
** sym_path: design/div2_cml_ls.sym
** sch_path: design/div2_cml_ls.sch
.subckt div2_cml_ls INP INN IB QP QN VDD VSS
*.ipin INP
*.ipin INN
*.ipin IB
*.opin QP
*.opin QN
*.iopin VDD
*.iopin VSS
XEF INP INN IB CKP CKN VDD VSS cml_ef
XM QN QP CKP CKN IB MP MN VDD VSS cml_latch
XS MP MN CKN CKP IB QP QN VDD VSS cml_latch
.ends

* expanding   symbol:  cml_dff.sym # of pins=9
** sym_path: design/cml_dff.sym
** sch_path: design/cml_dff.sch
.subckt cml_dff D DB CK CKB IB Q QB VDD VSS
*.ipin D
*.ipin DB
*.ipin CK
*.ipin CKB
*.ipin IB
*.opin Q
*.opin QB
*.iopin VDD
*.iopin VSS
XM D DB CK CKB IB M MB VDD VSS cml_latch
XS M MB CKB CK IB Q QB VDD VSS cml_latch
.ends

* expanding   symbol:  cml_latch.sym # of pins=9
** sym_path: design/cml_latch.sym
** sch_path: design/cml_latch.sch
.subckt cml_latch D DB CK CKB IB Q QB VDD VSS
*.ipin D
*.ipin DB
*.ipin CK
*.ipin CKB
*.ipin IB
*.opin Q
*.opin QB
*.iopin VDD
*.iopin VSS
RL1 VDD Q 2400 m=1
RL2 VDD QB 2400 m=1
XQT1 QB D e1 VSS npn13G2v Nx=1 El=1
XQT2 Q DB e1 VSS npn13G2v Nx=1 El=1
XQH1 QB Q e2 VSS npn13G2v Nx=1 El=1
XQH2 Q QB e2 VSS npn13G2v Nx=1 El=1
XQC1 e1 CK t VSS npn13G2v Nx=1 El=1
XQC2 e2 CKB t VSS npn13G2v Nx=1 El=1
XQT t IB teT VSS npn13G2v Nx=2 El=1
RT teT VSS 1200 m=1
.ends

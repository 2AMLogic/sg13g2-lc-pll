* sg13g2-lc-pll :: loopfilter -- generated by design/netlist.sh (klt netlist) from design/loopfilter.sch
* do not edit by hand.
** sch_path: design/loopfilter.sch
.subckt loopfilter VIN VCTRL VSS
*.ipin VIN
*.opin VCTRL
*.iopin VSS
XR1 VIN nz1 VSS rppd w=2u l=53.9u m=1 b=0
XC1 nz1 VSS cap_cmim w=70.9u l=70.9u m=12
XC2 VIN VSS cap_cmim w=63.4u l=63.4u m=1
XR3 VIN VCTRL VSS rppd w=2u l=53.9u m=1 b=0
XC3 VCTRL VSS cap_cmim w=43.4u l=43.4u m=1
.ends

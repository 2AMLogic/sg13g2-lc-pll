* sg13g2-lc-pll :: cp -- generated by design/netlist.sh (klt netlist) from design/cp.sch
* do not edit by hand.
** sch_path: design/cp.sch
.subckt cp UP DN IREF VOUT VDD VSS
*.ipin UP
*.ipin DN
*.ipin IREF
*.opin VOUT
*.iopin VDD
*.iopin VSS
XIUP_P UPB UP VDD VDD sg13_hv_pmos w=5u l=0.5u ng=1 m=1
XIUP_N UPB UP VSS VSS sg13_hv_nmos w=2u l=0.5u ng=1 m=1
XIDN_P DNB DN VDD VDD sg13_hv_pmos w=5u l=0.5u ng=1 m=1
XIDN_N DNB DN VSS VSS sg13_hv_nmos w=2u l=0.5u ng=1 m=1
XBIAS IREF IBP ICN ICP VDD VSS cp_bias
XLEGP IBP ICP UP UPB VOUT VDUMP VDD cp_leg_p
XLEGN IREF ICN DN DNB VOUT VDUMP VSS cp_leg_n
XBUF VOUT IREF VDUMP VDD VSS cp_dumpbuf
.ends

* expanding   symbol:  cp_bias.sym # of pins=6
** sym_path: design/cp_bias.sym
** sch_path: design/cp_bias.sch
.subckt cp_bias IREF IBP ICN ICP VDD VSS
*.ipin IREF
*.opin IBP
*.opin ICN
*.opin ICP
*.iopin VDD
*.iopin VSS
XBN1 IREF IREF VSS VSS sg13_hv_nmos w=4u l=1u ng=1 m=1
XBN2 IBP IREF VSS VSS sg13_hv_nmos w=4u l=1u ng=1 m=1
XBP1 IBP IBP VDD VDD sg13_hv_pmos w=4u l=1u ng=1 m=1
XBPS ICN IBP VDD VDD sg13_hv_pmos w=4u l=1u ng=1 m=1
XBNC ICN ICN nx VSS sg13_hv_nmos w=2u l=1u ng=1 m=1
XBNA nx IREF VSS VSS sg13_hv_nmos w=4u l=1u ng=1 m=1
XBPA px IBP VDD VDD sg13_hv_pmos w=4u l=1u ng=1 m=1
XBPC ICP ICP px VDD sg13_hv_pmos w=3u l=1u ng=1 m=1
XBNS ICP IREF VSS VSS sg13_hv_nmos w=4u l=1u ng=1 m=1
.ends

* expanding   symbol:  cp_leg_p.sym # of pins=7
** sym_path: design/cp_leg_p.sym
** sch_path: design/cp_leg_p.sch
.subckt cp_leg_p IBP ICP UP UPB VOUT VDUMP VDD
*.ipin IBP
*.ipin ICP
*.ipin UP
*.ipin UPB
*.opin VOUT
*.opin VDUMP
*.iopin VDD
XM1 tail IBP VDD VDD sg13_hv_pmos w=3.8u l=1u ng=1 m=10
XM2 sw ICP tail VDD sg13_hv_pmos w=3.8u l=1u ng=1 m=10
XSWO VOUT UPB sw VDD sg13_hv_pmos w=6u l=0.3u ng=1 m=1
XSWD VDUMP UP sw VDD sg13_hv_pmos w=6u l=0.3u ng=1 m=1
.ends

* expanding   symbol:  cp_leg_n.sym # of pins=7
** sym_path: design/cp_leg_n.sym
** sch_path: design/cp_leg_n.sch
.subckt cp_leg_n IBN ICN DN DNB VOUT VDUMP VSS
*.ipin IBN
*.ipin ICN
*.ipin DN
*.ipin DNB
*.opin VOUT
*.opin VDUMP
*.iopin VSS
XM1 tail IBN VSS VSS sg13_hv_nmos w=3.8u l=1u ng=1 m=10
XM2 sw ICN tail VSS sg13_hv_nmos w=3.8u l=1u ng=1 m=10
XSWO VOUT DN sw VSS sg13_hv_nmos w=6u l=0.3u ng=1 m=1
XSWD VDUMP DNB sw VSS sg13_hv_nmos w=6u l=0.3u ng=1 m=1
.ends

* expanding   symbol:  cp_dumpbuf.sym # of pins=5
** sym_path: design/cp_dumpbuf.sym
** sch_path: design/cp_dumpbuf.sch
.subckt cp_dumpbuf VOUT IBIAS VDUMP VDD VSS
*.ipin VOUT
*.ipin IBIAS
*.opin VDUMP
*.iopin VDD
*.iopin VSS
XM1 VDD VOUT VDUMP VSS sg13_hv_nmos w=6u l=0.5u ng=1 m=1
XM2 VDUMP IBIAS VSS VSS sg13_hv_nmos w=4u l=1u ng=1 m=5
.ends

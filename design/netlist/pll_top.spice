* sg13g2-lc-pll :: pll_top -- generated by design/netlist.sh (klt netlist) from design/pll_top.sch
* do not edit by hand.
** sch_path: design/pll_top.sch
.subckt pll_top REF IREFCP IREFPS LOCK VCTRL FB VDD VDDV VSS
*.ipin REF
*.ipin IREFCP
*.ipin IREFPS
*.opin LOCK
*.opin VCTRL
*.opin FB
*.iopin VDD
*.iopin VDDV
*.iopin VSS
XPFD REF FB UP DN VDD VSS pfd
XCP UP DN IREFCP VCP VDD VSS cp
XLF VCP VCTRL VSS loopfilter
XVCO VCTRL VOP VON VDDV VSS vco
XPS VOP VON MC IREFPS PSP PSN VDD VSS prescaler
XDIV PSP PSN IREFPS VSS VSS VDD VDD VSS VDD MC FB VDD VSS divider
XLD UP DN LOCK VDD VSS lock_detector
.ends

* expanding   symbol:  pfd.sym # of pins=6
** sym_path: .fetched/sg13g2-pll/design/pfd.sym
** sch_path: .fetched/sg13g2-pll/design/pfd.sch
.subckt pfd REF FB UP DN VDD VSS
*.ipin REF
*.ipin FB
*.opin UP
*.opin DN
*.iopin VDD
*.iopin VSS
XED_UP REF set_up VDD VSS edgedet
XED_DN FB set_dn VDD VSS edgedet
XLU set_up reset UP net1 VDD VSS srlatch
XLD set_dn reset DN net2 VDD VSS srlatch
XNR UP DN reset_raw VDD VSS nand2_hv
XI1 reset_raw reset_d1 VDD VSS inv_hv
XI1B reset_d1 reset_d2 VDD VSS inv_hv
XI2 reset_d2 reset VDD VSS inv2x_hv
.ends

* expanding   symbol:  cp.sym # of pins=6
** sym_path: design/cp.sym
** sch_path: design/cp.sch
.subckt cp UP DN IREF VOUT VDD VSS
*.ipin UP
*.ipin DN
*.ipin IREF
*.opin VOUT
*.iopin VDD
*.iopin VSS
XIUP_P UPB UP VDD VDD sg13_hv_pmos w=5u l=0.5u ng=1 m=1
XIUP_N UPB UP VSS VSS sg13_hv_nmos w=2u l=0.5u ng=1 m=1
XIDN_P DNB DN VDD VDD sg13_hv_pmos w=5u l=0.5u ng=1 m=1
XIDN_N DNB DN VSS VSS sg13_hv_nmos w=2u l=0.5u ng=1 m=1
XBIAS IREF IBP ICN ICP VDD VSS cp_bias
XLEGP IBP ICP UP UPB VOUT VDUMP VDD cp_leg_p
XLEGN IREF ICN DN DNB VOUT VDUMP VSS cp_leg_n
XBUF VOUT IREF VDUMP VDD VSS cp_dumpbuf
.ends

* expanding   symbol:  loopfilter.sym # of pins=3
** sym_path: design/loopfilter.sym
** sch_path: design/loopfilter.sch
.subckt loopfilter VIN VCTRL VSS
*.ipin VIN
*.opin VCTRL
*.iopin VSS
XR1 VIN nz1 VSS rppd w=2u l=53.9u m=1 b=0
XC1 nz1 VSS cap_cmim w=70.9u l=70.9u m=12
XC2 VIN VSS cap_cmim w=63.4u l=63.4u m=1
XR3 VIN VCTRL VSS rppd w=2u l=53.9u m=1 b=0
XC3 VCTRL VSS cap_cmim w=43.4u l=43.4u m=1
.ends

* expanding   symbol:  prescaler.sym # of pins=8
** sym_path: design/prescaler.sym
** sch_path: design/prescaler.sch
.subckt prescaler INP INN MC IREF OUTP OUTN VDD VSS
*.ipin INP
*.ipin INN
*.ipin MC
*.ipin IREF
*.opin OUTP
*.opin OUTN
*.iopin VDD
*.iopin VSS
XQREF IREF IREF reref VSS npn13G2v Nx=1 El=1
RREF reref VSS 2400 m=1
X2 INP INN IREF HP HN VDD VSS div2_cml
X45 HP HN MC IREF OUTP OUTN VDD VSS div45_dm
.ends

* expanding   symbol:  divider.sym # of pins=13
** sym_path: design/divider.sym
** sch_path: design/divider.sch
.subckt divider INP INN IREF M0 M1 M2 M3 A0 A1 MC FB VDD VSS
*.ipin INP
*.ipin INN
*.ipin IREF
*.ipin M0
*.ipin M1
*.ipin M2
*.ipin M3
*.ipin A0
*.ipin A1
*.opin MC
*.opin FB
*.iopin VDD
*.iopin VSS
XCV INP INN IREF CK VDD VSS cml2cmos
XM CK M0 M1 M2 M3 TC TCN VDD VSS mcounter
XA CK TC TCN A0 A1 MC VDD VSS acounter
XFB TC CK FB VDD VSS dff_tg_hv
.ends

* expanding   symbol:  lock_detector.sym # of pins=5
** sym_path: .fetched/sg13g2-pll/design/lock_detector.sym
** sch_path: .fetched/sg13g2-pll/design/lock_detector.sch
.subckt lock_detector UP DN LOCK VDD VSS
*.ipin UP
*.ipin DN
*.opin LOCK
*.iopin VDD
*.iopin VSS
XXOR UP DN ERR VDD VSS xor2_hv
XDW ERR ERRD VDD VSS delaywin_hv
XNW ERR ERRD nwide VDD VSS nand2_hv
XIW nwide WIDE VDD VSS inv_hv
XRPU VDD VWIN sub! rhigh w=0.5u l=500u m=1 b=0
XMPD VWIN WIDE VSS VSS sg13_hv_nmos w=0.25u l=12u ng=1 m=1
XCW VWIN VSS cap_cmim w=45u l=45u m=1
XSCH VWIN LOCK VDD VSS schmitt_hv
.ends

* expanding   symbol:  edgedet.sym # of pins=4
** sym_path: .fetched/sg13g2-pll/design/edgedet.sym
** sch_path: .fetched/sg13g2-pll/design/edgedet.sch
.subckt edgedet X OUT VDD VSS
*.ipin X
*.opin OUT
*.iopin VDD
*.iopin VSS
XD1 X d1 VDD VSS inv_hv
XD2 d1 d2 VDD VSS inv_hv
XD3 d2 d3 VDD VSS inv_hv
XD4 d3 d4 VDD VSS inv_hv
XD5 d4 XD5 VDD VSS inv_hv
XN1 X XD5 ntmp VDD VSS nand2_hv
XOUT ntmp OUT VDD VSS inv_hv
.ends

* expanding   symbol:  srlatch.sym # of pins=6
** sym_path: .fetched/sg13g2-pll/design/srlatch.sym
** sch_path: .fetched/sg13g2-pll/design/srlatch.sch
.subckt srlatch S R Q QB VDD VSS
*.ipin S
*.ipin R
*.opin Q
*.opin QB
*.iopin VDD
*.iopin VSS
XIS S SB VDD VSS inv_hv
XIR R RB VDD VSS inv_hv
XNQ SB QB Q VDD VSS nand2_hv
XNQB RB Q QB VDD VSS nand2_hv
.ends

* expanding   symbol:  nand2_hv.sym # of pins=5
** sym_path: .fetched/sg13g2-pll/design/nand2_hv.sym
** sch_path: .fetched/sg13g2-pll/design/nand2_hv.sch
.subckt nand2_hv A1 A2 Y VDD VSS
*.opin Y
*.ipin A1
*.ipin A2
*.iopin VDD
*.iopin VSS
XMP1 Y A1 VDD VDD sg13_hv_pmos w=5u l=0.5u ng=1 m=1
XMP2 Y A2 VDD VDD sg13_hv_pmos w=5u l=0.5u ng=1 m=1
XMN1 Y A1 mid1 VSS sg13_hv_nmos w=2u l=0.5u ng=1 m=1
XMN2 mid1 A2 VSS VSS sg13_hv_nmos w=2u l=0.5u ng=1 m=1
.ends

* expanding   symbol:  inv_hv.sym # of pins=4
** sym_path: .fetched/sg13g2-pll/design/inv_hv.sym
** sch_path: .fetched/sg13g2-pll/design/inv_hv.sch
.subckt inv_hv A Y VDD VSS
*.ipin A
*.opin Y
*.iopin VDD
*.iopin VSS
XMP Y A VDD VDD sg13_hv_pmos w=5u l=0.5u ng=1 m=1
XMN Y A VSS VSS sg13_hv_nmos w=2u l=0.5u ng=1 m=1
.ends

* expanding   symbol:  inv2x_hv.sym # of pins=4
** sym_path: .fetched/sg13g2-pll/design/inv2x_hv.sym
** sch_path: .fetched/sg13g2-pll/design/inv2x_hv.sch
.subckt inv2x_hv A Y VDD VSS
*.ipin A
*.opin Y
*.iopin VDD
*.iopin VSS
XMP Y A VDD VDD sg13_hv_pmos w=10u l=0.5u ng=1 m=1
XMN Y A VSS VSS sg13_hv_nmos w=4u l=0.5u ng=1 m=1
.ends

* expanding   symbol:  cp_bias.sym # of pins=6
** sym_path: design/cp_bias.sym
** sch_path: design/cp_bias.sch
.subckt cp_bias IREF IBP ICN ICP VDD VSS
*.ipin IREF
*.opin IBP
*.opin ICN
*.opin ICP
*.iopin VDD
*.iopin VSS
XBN1 IREF IREF VSS VSS sg13_hv_nmos w=4u l=1u ng=1 m=1
XBN2 IBP IREF VSS VSS sg13_hv_nmos w=4u l=1u ng=1 m=1
XBP1 IBP IBP VDD VDD sg13_hv_pmos w=4u l=1u ng=1 m=1
XBPS ICN IBP VDD VDD sg13_hv_pmos w=4u l=1u ng=1 m=1
XBNC ICN ICN nx VSS sg13_hv_nmos w=2u l=1u ng=1 m=1
XBNA nx IREF VSS VSS sg13_hv_nmos w=4u l=1u ng=1 m=1
XBPA px IBP VDD VDD sg13_hv_pmos w=4u l=1u ng=1 m=1
XBPC ICP ICP px VDD sg13_hv_pmos w=3u l=1u ng=1 m=1
XBNS ICP IREF VSS VSS sg13_hv_nmos w=4u l=1u ng=1 m=1
.ends

* expanding   symbol:  cp_leg_p.sym # of pins=7
** sym_path: design/cp_leg_p.sym
** sch_path: design/cp_leg_p.sch
.subckt cp_leg_p IBP ICP UP UPB VOUT VDUMP VDD
*.ipin IBP
*.ipin ICP
*.ipin UP
*.ipin UPB
*.opin VOUT
*.opin VDUMP
*.iopin VDD
XM1 tail IBP VDD VDD sg13_hv_pmos w=3.8u l=1u ng=1 m=10
XM2 sw ICP tail VDD sg13_hv_pmos w=3.8u l=1u ng=1 m=10
XSWO VOUT UPB sw VDD sg13_hv_pmos w=6u l=0.3u ng=1 m=1
XSWD VDUMP UP sw VDD sg13_hv_pmos w=6u l=0.3u ng=1 m=1
.ends

* expanding   symbol:  cp_leg_n.sym # of pins=7
** sym_path: design/cp_leg_n.sym
** sch_path: design/cp_leg_n.sch
.subckt cp_leg_n IBN ICN DN DNB VOUT VDUMP VSS
*.ipin IBN
*.ipin ICN
*.ipin DN
*.ipin DNB
*.opin VOUT
*.opin VDUMP
*.iopin VSS
XM1 tail IBN VSS VSS sg13_hv_nmos w=3.8u l=1u ng=1 m=10
XM2 sw ICN tail VSS sg13_hv_nmos w=3.8u l=1u ng=1 m=10
XSWO VOUT DN sw VSS sg13_hv_nmos w=6u l=0.3u ng=1 m=1
XSWD VDUMP DNB sw VSS sg13_hv_nmos w=6u l=0.3u ng=1 m=1
.ends

* expanding   symbol:  cp_dumpbuf.sym # of pins=5
** sym_path: design/cp_dumpbuf.sym
** sch_path: design/cp_dumpbuf.sch
.subckt cp_dumpbuf VOUT IBIAS VDUMP VDD VSS
*.ipin VOUT
*.ipin IBIAS
*.opin VDUMP
*.iopin VDD
*.iopin VSS
XM1 VDD VOUT VDUMP VSS sg13_hv_nmos w=6u l=0.5u ng=1 m=1
XM2 VDUMP IBIAS VSS VSS sg13_hv_nmos w=4u l=1u ng=1 m=5
.ends

* expanding   symbol:  div2_cml.sym # of pins=7
** sym_path: design/div2_cml.sym
** sch_path: design/div2_cml.sch
.subckt div2_cml INP INN IB QP QN VDD VSS
*.ipin INP
*.ipin INN
*.ipin IB
*.opin QP
*.opin QN
*.iopin VDD
*.iopin VSS
XEF INP INN IB CKP CKN VDD VSS div2_ef_hs
XM QN QP CKP CKN IB MP MN VDD VSS div2_latch_hs
XS MP MN CKN CKP IB QP QN VDD VSS div2_latch_hs
.ends

* expanding   symbol:  div45_dm.sym # of pins=8
** sym_path: design/div45_dm.sym
** sch_path: design/div45_dm.sch
.subckt div45_dm INP INN MC IB OUTP OUTN VDD VSS
*.ipin INP
*.ipin INN
*.ipin MC
*.ipin IB
*.opin OUTP
*.opin OUTN
*.iopin VDD
*.iopin VSS
XMC MC IB MCP MCN VDD VSS mc_conv
XMCL MCP MCN IB MCL MCLB VDD VSS cml_ef
XGM OUTP OUTN MCL MCLB IB M MB VDD VSS cml_and2
XC23 INP INN M MB IB C1 C1B VDD VSS cml_div23
XT C1 C1B IB OUTP OUTN VDD VSS div2_cml_ls
.ends

* expanding   symbol:  cml2cmos.sym # of pins=6
** sym_path: design/cml2cmos.sym
** sch_path: design/cml2cmos.sch
.subckt cml2cmos INP INN IREF CK VDD VSS
*.ipin INP
*.ipin INN
*.ipin IREF
*.opin CK
*.iopin VDD
*.iopin VSS
XQT tail IREF te VSS npn13G2v Nx=4 El=1
RT te VSS 600 m=1
XCC1 INP gp cap_cmim w=14u l=14u m=1
XCC2 INN gn cap_cmim w=14u l=14u m=1
RB1 vb gp 50k m=1
RB2 vb gn 50k m=1
RV1 VDD vb 50k m=1
RV2 vb VSS 50k m=1
XM1 d1 gp tail VSS sg13_hv_nmos w=10u l=0.5u ng=1 m=1
XM2 cmo gn tail VSS sg13_hv_nmos w=10u l=0.5u ng=1 m=1
XP1 d1 d1 VDD VDD sg13_hv_pmos w=10u l=0.5u ng=1 m=1
XP2 cmo d1 VDD VDD sg13_hv_pmos w=10u l=0.5u ng=1 m=1
XI1 cmo cmob VDD VSS inv_hv
XI2 cmob CK VDD VSS inv_hv
.ends

* expanding   symbol:  mcounter.sym # of pins=9
** sym_path: design/mcounter.sym
** sch_path: design/mcounter.sch
.subckt mcounter CK M0 M1 M2 M3 TC TCN VDD VSS
*.ipin CK
*.ipin M0
*.ipin M1
*.ipin M2
*.ipin M3
*.opin TC
*.opin TCN
*.iopin VDD
*.iopin VSS
XQ0 D0 CK q0 VDD VSS dff_tg_hv
XQ1 D1 CK q1 VDD VSS dff_tg_hv
XQ2 D2 CK q2 VDD VSS dff_tg_hv
XQ3 D3 CK q3 VDD VSS dff_tg_hv
XTC1 q1 q2 n12 VDD VSS nor2_hv
XTC2 q3 q3b VDD VSS inv_hv
XTC3 q0 n12 q3b TCN VDD VSS nand3_hv
XTC4 TCN TC VDD VSS inv_hv
XD0 q0 dec0 VDD VSS inv_hv
XD1 q1 dec0 dec1 VDD VSS xor2_hv
XD2A q1 q0 n10 VDD VSS nor2_hv
XD2 q2 n10 dec2 VDD VSS xor2_hv
XD3A n10 n10b VDD VSS inv_hv
XD3B q2 n10b n210 VDD VSS nor2_hv
XD3 q3 n210 dec3 VDD VSS xor2_hv
XNL0A dec0 TCN L0_na VDD VSS nand2_hv
XNL0B M0 TC L0_nb VDD VSS nand2_hv
XNL0Y L0_na L0_nb D0 VDD VSS nand2_hv
XNL1A dec1 TCN L1_na VDD VSS nand2_hv
XNL1B M1 TC L1_nb VDD VSS nand2_hv
XNL1Y L1_na L1_nb D1 VDD VSS nand2_hv
XNL2A dec2 TCN L2_na VDD VSS nand2_hv
XNL2B M2 TC L2_nb VDD VSS nand2_hv
XNL2Y L2_na L2_nb D2 VDD VSS nand2_hv
XNL3A dec3 TCN L3_na VDD VSS nand2_hv
XNL3B M3 TC L3_nb VDD VSS nand2_hv
XNL3Y L3_na L3_nb D3 VDD VSS nand2_hv
.ends

* expanding   symbol:  acounter.sym # of pins=8
** sym_path: design/acounter.sym
** sch_path: design/acounter.sch
.subckt acounter CK TC TCN A0 A1 MC VDD VSS
*.ipin CK
*.ipin TC
*.ipin TCN
*.ipin A0
*.ipin A1
*.opin MC
*.iopin VDD
*.iopin VSS
XQ0 D0 CK s0 VDD VSS dff_tg_hv
XQ1 D1 CK s1 VDD VSS dff_tg_hv
XZ1 s0 s1 zb VDD VSS nor2_hv
XZ2 zb MC VDD VSS inv_hv
XD0 s0 MC dec0 VDD VSS xor2_hv
XD1A s0 zb brw VDD VSS nor2_hv
XD1 s1 brw dec1 VDD VSS xor2_hv
XNL0A dec0 TCN L0_na VDD VSS nand2_hv
XNL0B A0 TC L0_nb VDD VSS nand2_hv
XNL0Y L0_na L0_nb D0 VDD VSS nand2_hv
XNL1A dec1 TCN L1_na VDD VSS nand2_hv
XNL1B A1 TC L1_nb VDD VSS nand2_hv
XNL1Y L1_na L1_nb D1 VDD VSS nand2_hv
.ends

* expanding   symbol:  dff_tg_hv.sym # of pins=5
** sym_path: .fetched/sg13g2-pll/design/dff_tg_hv.sym
** sch_path: .fetched/sg13g2-pll/design/dff_tg_hv.sch
.subckt dff_tg_hv D CLK Q VDD VSS
*.ipin D
*.ipin CLK
*.opin Q
*.iopin VDD
*.iopin VSS
XICLK CLK CLKB VDD VSS inv_hv
XICKBB CLKB CKBB VDD VSS inv_hv
XTG1 D CLKB CKBB M VDD VSS tgate_hv
XIM M MB VDD VSS inv_hv
XIMF MB MFB VDD VSS inv_hv
XTGFBM MFB CKBB CLKB M VDD VSS tgate_hv
XTG2 M CKBB CLKB S VDD VSS tgate_hv
XIS S SB VDD VSS inv_hv
XISF SB SFB VDD VSS inv_hv
XTGFBS SFB CLKB CKBB S VDD VSS tgate_hv
XBQ SB Q VDD VSS inv_hv
.ends

* expanding   symbol:  xor2_hv.sym # of pins=5
** sym_path: .fetched/sg13g2-pll/design/xor2_hv.sym
** sch_path: .fetched/sg13g2-pll/design/xor2_hv.sch
.subckt xor2_hv A B Y VDD VSS
*.ipin A
*.ipin B
*.opin Y
*.iopin VDD
*.iopin VSS
XN1 A B n1 VDD VSS nand2_hv
XN2 A n1 n2 VDD VSS nand2_hv
XN3 B n1 n3 VDD VSS nand2_hv
XN4 n2 n3 Y VDD VSS nand2_hv
.ends

* expanding   symbol:  delaywin_hv.sym # of pins=4
** sym_path: .fetched/sg13g2-pll/design/delaywin_hv.sym
** sch_path: .fetched/sg13g2-pll/design/delaywin_hv.sch
.subckt delaywin_hv IN OUT VDD VSS
*.ipin IN
*.opin OUT
*.iopin VDD
*.iopin VSS
XI1 IN d1 VDD VSS inv_hv
XI2 d1 d2 VDD VSS inv_hv
XI3 d2 d3 VDD VSS inv_hv
XI4 d3 OUT VDD VSS inv_hv
XC1 OUT VSS cap_cmim w=45u l=45u m=1
.ends

* expanding   symbol:  schmitt_hv.sym # of pins=4
** sym_path: .fetched/sg13g2-pll/design/schmitt_hv.sym
** sch_path: .fetched/sg13g2-pll/design/schmitt_hv.sch
.subckt schmitt_hv IN OUT VDD VSS
*.ipin IN
*.opin OUT
*.iopin VDD
*.iopin VSS
XMP1 np IN VDD VDD sg13_hv_pmos w=5u l=2u ng=1 m=1
XMP2 OUT IN np VDD sg13_hv_pmos w=5u l=2u ng=1 m=1
XMP3 VSS OUT np VDD sg13_hv_pmos w=5u l=2u ng=1 m=1
XMN1 OUT IN nn VSS sg13_hv_nmos w=2u l=2u ng=1 m=1
XMN2 nn IN VSS VSS sg13_hv_nmos w=2u l=2u ng=1 m=1
XMN3 VDD OUT nn VSS sg13_hv_nmos w=2u l=2u ng=1 m=1
.ends

* expanding   symbol:  div2_ef_hs.sym # of pins=7
** sym_path: design/div2_ef_hs.sym
** sch_path: design/div2_ef_hs.sch
.subckt div2_ef_hs IN INB IB OUT OUTB VDD VSS
*.ipin IN
*.ipin INB
*.ipin IB
*.opin OUT
*.opin OUTB
*.iopin VDD
*.iopin VSS
XQE1 VDD IN OUT VSS npn13G2v Nx=1 El=1
XQE2 VDD INB OUTB VSS npn13G2v Nx=1 El=1
XQF1 OUT IB f1 VSS npn13G2v Nx=1 El=1
RF1 f1 VSS 2400 m=1
XQF2 OUTB IB f2 VSS npn13G2v Nx=1 El=1
RF2 f2 VSS 2400 m=1
.ends

* expanding   symbol:  div2_latch_hs.sym # of pins=9
** sym_path: design/div2_latch_hs.sym
** sch_path: design/div2_latch_hs.sch
.subckt div2_latch_hs D DB CK CKB IB Q QB VDD VSS
*.ipin D
*.ipin DB
*.ipin CK
*.ipin CKB
*.ipin IB
*.opin Q
*.opin QB
*.iopin VDD
*.iopin VSS
RL1 VDD Q 1500 m=1
RL2 VDD QB 1500 m=1
XQT1 QB D e1 VSS npn13G2v Nx=1 El=1
XQT2 Q DB e1 VSS npn13G2v Nx=1 El=1
XQH1 QB Q e2 VSS npn13G2v Nx=1 El=1
XQH2 Q QB e2 VSS npn13G2v Nx=1 El=1
XQC1 e1 CK t VSS npn13G2v Nx=1 El=1
XQC2 e2 CKB t VSS npn13G2v Nx=1 El=1
XQT t IB teT VSS npn13G2v Nx=4 El=1
RT teT VSS 600 m=1
.ends

* expanding   symbol:  mc_conv.sym # of pins=6
** sym_path: design/mc_conv.sym
** sch_path: design/mc_conv.sch
.subckt mc_conv MC IB MCP MCN VDD VSS
*.ipin MC
*.ipin IB
*.opin MCP
*.opin MCN
*.iopin VDD
*.iopin VSS
RIN MC bm 20k m=1
RD1 VDD vr 20k m=1
RD2 vr VSS 20k m=1
RL1 VDD MCP 2400 m=1
RL2 VDD MCN 2400 m=1
XQM1 MCN bm t VSS npn13G2v Nx=1 El=1
XQM2 MCP vr t VSS npn13G2v Nx=1 El=1
XQT t IB teT VSS npn13G2v Nx=2 El=1
RT teT VSS 1200 m=1
.ends

* expanding   symbol:  cml_ef.sym # of pins=7
** sym_path: design/cml_ef.sym
** sch_path: design/cml_ef.sch
.subckt cml_ef IN INB IB OUT OUTB VDD VSS
*.ipin IN
*.ipin INB
*.ipin IB
*.opin OUT
*.opin OUTB
*.iopin VDD
*.iopin VSS
XQE1 VDD IN OUT VSS npn13G2v Nx=1 El=1
XQE2 VDD INB OUTB VSS npn13G2v Nx=1 El=1
XQF1 OUT IB f1 VSS npn13G2v Nx=1 El=1
RF1 f1 VSS 2400 m=1
XQF2 OUTB IB f2 VSS npn13G2v Nx=1 El=1
RF2 f2 VSS 2400 m=1
.ends

* expanding   symbol:  cml_and2.sym # of pins=9
** sym_path: design/cml_and2.sym
** sch_path: design/cml_and2.sch
.subckt cml_and2 A AB B BB IB Q QB VDD VSS
*.ipin A
*.ipin AB
*.ipin B
*.ipin BB
*.ipin IB
*.opin Q
*.opin QB
*.iopin VDD
*.iopin VSS
RL1 VDD Q 2400 m=1
RL2 VDD QB 2400 m=1
XQA1 QB A n1 VSS npn13G2v Nx=1 El=1
XQA2 Q AB n1 VSS npn13G2v Nx=1 El=1
XQB1 n1 B t VSS npn13G2v Nx=1 El=1
XQB2 Q BB t VSS npn13G2v Nx=1 El=1
XQT t IB teT VSS npn13G2v Nx=2 El=1
RT teT VSS 1200 m=1
.ends

* expanding   symbol:  cml_div23.sym # of pins=9
** sym_path: design/cml_div23.sym
** sch_path: design/cml_div23.sch
.subckt cml_div23 INP INN M MB IB Q1 Q1B VDD VSS
*.ipin INP
*.ipin INN
*.ipin M
*.ipin MB
*.ipin IB
*.opin Q1
*.opin Q1B
*.iopin VDD
*.iopin VSS
XCK INP INN IB CKP CKN VDD VSS cml_ef
XQ1L Q1 Q1B IB Q1L Q1LB VDD VSS cml_ef
XG1 Q2B Q2 Q1LB Q1L IB D1 D1B VDD VSS cml_and2
XG2 M MB Q1L Q1LB IB D2 D2B VDD VSS cml_and2
XF1 D1 D1B CKP CKN IB Q1 Q1B VDD VSS cml_dff
XF2 D2 D2B CKP CKN IB Q2 Q2B VDD VSS cml_dff
.ends

* expanding   symbol:  div2_cml_ls.sym # of pins=7
** sym_path: design/div2_cml_ls.sym
** sch_path: design/div2_cml_ls.sch
.subckt div2_cml_ls INP INN IB QP QN VDD VSS
*.ipin INP
*.ipin INN
*.ipin IB
*.opin QP
*.opin QN
*.iopin VDD
*.iopin VSS
XEF INP INN IB CKP CKN VDD VSS cml_ef
XM QN QP CKP CKN IB MP MN VDD VSS cml_latch
XS MP MN CKN CKP IB QP QN VDD VSS cml_latch
.ends

* expanding   symbol:  nor2_hv.sym # of pins=5
** sym_path: .fetched/sg13g2-pll/design/nor2_hv.sym
** sch_path: .fetched/sg13g2-pll/design/nor2_hv.sch
.subckt nor2_hv A B Y VDD VSS
*.ipin A
*.ipin B
*.opin Y
*.iopin VDD
*.iopin VSS
XMP1 midp A VDD VDD sg13_hv_pmos w=5u l=0.5u ng=1 m=1
XMP2 Y B midp VDD sg13_hv_pmos w=5u l=0.5u ng=1 m=1
XMN1 Y A VSS VSS sg13_hv_nmos w=2u l=0.5u ng=1 m=1
XMN2 Y B VSS VSS sg13_hv_nmos w=2u l=0.5u ng=1 m=1
.ends

* expanding   symbol:  nand3_hv.sym # of pins=6
** sym_path: .fetched/sg13g2-pll/design/nand3_hv.sym
** sch_path: .fetched/sg13g2-pll/design/nand3_hv.sch
.subckt nand3_hv A1 A2 A3 Y VDD VSS
*.opin Y
*.ipin A1
*.ipin A2
*.ipin A3
*.iopin VDD
*.iopin VSS
XMP1 Y A1 VDD VDD sg13_hv_pmos w=5u l=0.5u ng=1 m=1
XMP2 Y A2 VDD VDD sg13_hv_pmos w=5u l=0.5u ng=1 m=1
XMP3 Y A3 VDD VDD sg13_hv_pmos w=5u l=0.5u ng=1 m=1
XMN1 Y A1 mid1 VSS sg13_hv_nmos w=2u l=0.5u ng=1 m=1
XMN2 mid1 A2 mid2 VSS sg13_hv_nmos w=2u l=0.5u ng=1 m=1
XMN3 mid2 A3 VSS VSS sg13_hv_nmos w=2u l=0.5u ng=1 m=1
.ends

* expanding   symbol:  tgate_hv.sym # of pins=6
** sym_path: .fetched/sg13g2-pll/design/tgate_hv.sym
** sch_path: .fetched/sg13g2-pll/design/tgate_hv.sch
.subckt tgate_hv A NG PG Y VDD VSS
*.ipin A
*.opin Y
*.ipin NG
*.ipin PG
*.iopin VDD
*.iopin VSS
XMN A NG Y VSS sg13_hv_nmos w=2u l=0.5u ng=1 m=1
XMP Y PG A VDD sg13_hv_pmos w=5u l=0.5u ng=1 m=1
.ends

* expanding   symbol:  cml_dff.sym # of pins=9
** sym_path: design/cml_dff.sym
** sch_path: design/cml_dff.sch
.subckt cml_dff D DB CK CKB IB Q QB VDD VSS
*.ipin D
*.ipin DB
*.ipin CK
*.ipin CKB
*.ipin IB
*.opin Q
*.opin QB
*.iopin VDD
*.iopin VSS
XM D DB CK CKB IB M MB VDD VSS cml_latch
XS M MB CKB CK IB Q QB VDD VSS cml_latch
.ends

* expanding   symbol:  cml_latch.sym # of pins=9
** sym_path: design/cml_latch.sym
** sch_path: design/cml_latch.sch
.subckt cml_latch D DB CK CKB IB Q QB VDD VSS
*.ipin D
*.ipin DB
*.ipin CK
*.ipin CKB
*.ipin IB
*.opin Q
*.opin QB
*.iopin VDD
*.iopin VSS
RL1 VDD Q 2400 m=1
RL2 VDD QB 2400 m=1
XQT1 QB D e1 VSS npn13G2v Nx=1 El=1
XQT2 Q DB e1 VSS npn13G2v Nx=1 El=1
XQH1 QB Q e2 VSS npn13G2v Nx=1 El=1
XQH2 Q QB e2 VSS npn13G2v Nx=1 El=1
XQC1 e1 CK t VSS npn13G2v Nx=1 El=1
XQC2 e2 CKB t VSS npn13G2v Nx=1 El=1
XQT t IB teT VSS npn13G2v Nx=2 El=1
RT teT VSS 1200 m=1
.ends

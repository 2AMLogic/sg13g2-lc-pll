* sg13g2-lc-pll :: divider -- generated by design/netlist.sh (klt netlist) from design/divider.sch
* do not edit by hand.
** sch_path: design/divider.sch
.subckt divider INP INN IREF M0 M1 M2 M3 A0 A1 MC FB VDD VSS
*.ipin INP
*.ipin INN
*.ipin IREF
*.ipin M0
*.ipin M1
*.ipin M2
*.ipin M3
*.ipin A0
*.ipin A1
*.opin MC
*.opin FB
*.iopin VDD
*.iopin VSS
XCV INP INN IREF CK VDD VSS cml2cmos
XM CKL M0 M1 M2 M3 TC TCN VDD VSS mcounter
XA CKL TC TCN A0 A1 MC VDD VSS acounter
XFB TC CKL FB VDD VSS dff_tg_hv
XBA CK ckb VDD VSS inv_hv
XBB ckb CKL VDD VSS inv_hv
XBC ckb CKL VDD VSS inv_hv
XBD ckb CKL VDD VSS inv_hv
.ends

* expanding   symbol:  cml2cmos.sym # of pins=6
** sym_path: design/cml2cmos.sym
** sch_path: design/cml2cmos.sch
.subckt cml2cmos INP INN IREF CK VDD VSS
*.ipin INP
*.ipin INN
*.ipin IREF
*.opin CK
*.iopin VDD
*.iopin VSS
XQT tail IREF te VSS npn13G2v Nx=4 El=1
RT te VSS 600 m=1
XCC1 INP gp cap_cmim w=14u l=14u m=1
XCC2 INN gn cap_cmim w=14u l=14u m=1
RB1 vb gp 50k m=1
RB2 vb gn 50k m=1
RV1 VDD vb 50k m=1
RV2 vb VSS 50k m=1
XM1 d1 gp tail VSS sg13_hv_nmos w=10u l=0.5u ng=1 m=1
XM2 cmo gn tail VSS sg13_hv_nmos w=10u l=0.5u ng=1 m=1
XP1 d1 d1 VDD VDD sg13_hv_pmos w=10u l=0.5u ng=1 m=1
XP2 cmo d1 VDD VDD sg13_hv_pmos w=10u l=0.5u ng=1 m=1
XI1 cmo cmob VDD VSS inv_hv
XI2 cmob CK VDD VSS inv_hv
.ends

* expanding   symbol:  mcounter.sym # of pins=9
** sym_path: design/mcounter.sym
** sch_path: design/mcounter.sch
.subckt mcounter CK M0 M1 M2 M3 TC TCN VDD VSS
*.ipin CK
*.ipin M0
*.ipin M1
*.ipin M2
*.ipin M3
*.opin TC
*.opin TCN
*.iopin VDD
*.iopin VSS
XQ0 D0 CK q0 VDD VSS dff_tg_hv
XQ1 D1 CK q1 VDD VSS dff_tg_hv
XQ2 D2 CK q2 VDD VSS dff_tg_hv
XQ3 D3 CK q3 VDD VSS dff_tg_hv
XFT DT CK TC VDD VSS dff_tg_hv
XFTN DTN CK TCN VDD VSS dff_tg_hv
XFB1 DB1 CK b1 VDD VSS dff_tg_hv
XFB2 DB2 CK b2 VDD VSS dff_tg_hv
XFB3 DB3 CK b3 VDD VSS dff_tg_hv
XIQ0 q0 q0n VDD VSS inv_hv
XIQ1 q1 q1n VDD VSS inv_hv
XIQ2 q2 q2n VDD VSS inv_hv
XIQ3 q3 q3n VDD VSS inv_hv
XIB1 b1 b1n VDD VSS inv_hv
XIB2 b2 b2n VDD VSS inv_hv
XIB3 b3 b3n VDD VSS inv_hv
XZ1 M0 mz1 VDD VSS inv_hv
XZ2 M0 M1 mz2 VDD VSS nor2_hv
XZ3A M0 M1 z01 VDD VSS nor2_hv
XZ3C M2 M2n VDD VSS inv_hv
XZ3B z01 M2n mz3n VDD VSS nand2_hv
XZ3D mz3n mz3 VDD VSS inv_hv
XL0A q0n TCN l0a VDD VSS nand2_hv
XL0B M0 TC l0b VDD VSS nand2_hv
XL0Y l0a l0b D0 VDD VSS nand2_hv
XA1 b1 q1n a1 VDD VSS nand2_hv
XB1 b1n TCN q1 c1 VDD VSS nand3_hv
XL1B M1 TC l1b VDD VSS nand2_hv
XL1Y a1 c1 l1b D1 VDD VSS nand3_hv
XA2 b2 q2n a2 VDD VSS nand2_hv
XB2 b2n TCN q2 c2 VDD VSS nand3_hv
XL2B M2 TC l2b VDD VSS nand2_hv
XL2Y a2 c2 l2b D2 VDD VSS nand3_hv
XA3 b3 q3n a3 VDD VSS nand2_hv
XB3 b3n TCN q3 c3 VDD VSS nand3_hv
XL3B M3 TC l3b VDD VSS nand2_hv
XL3Y a3 c3 l3b D3 VDD VSS nand3_hv
XP1A TC mz1 p1a VDD VSS nand2_hv
XP1B TCN q0 p1b VDD VSS nand2_hv
XP1Y p1a p1b DB1 VDD VSS nand2_hv
XP2A TC mz2 p2a VDD VSS nand2_hv
XP2B TCN q0 q1n p2b VDD VSS nand3_hv
XP2Y p2a p2b DB2 VDD VSS nand2_hv
XP3E q1 q2 e12 VDD VSS nor2_hv
XP3A TC mz3 p3a VDD VSS nand2_hv
XP3B TCN q0 e12 p3b VDD VSS nand3_hv
XP3Y p3a p3b DB3 VDD VSS nand2_hv
XT1 q3 q2 f32 VDD VSS nor2_hv
XT2 q0 q1n g10 VDD VSS nor2_hv
XT3 f32 g10 DTN VDD VSS nand2_hv
XT4 DTN DT VDD VSS inv_hv
.ends

* expanding   symbol:  acounter.sym # of pins=8
** sym_path: design/acounter.sym
** sch_path: design/acounter.sch
.subckt acounter CK TC TCN A0 A1 MC VDD VSS
*.ipin CK
*.ipin TC
*.ipin TCN
*.ipin A0
*.ipin A1
*.opin MC
*.iopin VDD
*.iopin VSS
XQ0 D0 CK s0 VDD VSS dff_tg_hv
XQ1 D1 CK s1 VDD VSS dff_tg_hv
XQM DM CK MC VDD VSS dff_tg_hv
XS0 s0 s0n VDD VSS inv_hv
XL0A TCN s1 s0n l0a VDD VSS nand3_hv
XL0B A0 TC l0b VDD VSS nand2_hv
XL0Y l0a l0b D0 VDD VSS nand2_hv
XL1A TCN s1 s0 l1a VDD VSS nand3_hv
XL1B A1 TC l1b VDD VSS nand2_hv
XL1Y l1a l1b D1 VDD VSS nand2_hv
XNA0 A0 A0n VDD VSS inv_hv
XNA1 A1 A1n VDD VSS inv_hv
XNZ A0n A1n anz VDD VSS nand2_hv
XMA TC anz m1 VDD VSS nand2_hv
XMB TCN s1 m2 VDD VSS nand2_hv
XMY m1 m2 DM VDD VSS nand2_hv
.ends

* expanding   symbol:  dff_tg_hv.sym # of pins=5
** sym_path: .fetched/sg13g2-pll/design/dff_tg_hv.sym
** sch_path: .fetched/sg13g2-pll/design/dff_tg_hv.sch
.subckt dff_tg_hv D CLK Q VDD VSS
*.ipin D
*.ipin CLK
*.opin Q
*.iopin VDD
*.iopin VSS
XICLK CLK CLKB VDD VSS inv_hv
XICKBB CLKB CKBB VDD VSS inv_hv
XTG1 D CLKB CKBB M VDD VSS tgate_hv
XIM M MB VDD VSS inv_hv
XIMF MB MFB VDD VSS inv_hv
XTGFBM MFB CKBB CLKB M VDD VSS tgate_hv
XTG2 M CKBB CLKB S VDD VSS tgate_hv
XIS S SB VDD VSS inv_hv
XISF SB SFB VDD VSS inv_hv
XTGFBS SFB CLKB CKBB S VDD VSS tgate_hv
XBQ SB Q VDD VSS inv_hv
.ends

* expanding   symbol:  inv_hv.sym # of pins=4
** sym_path: .fetched/sg13g2-pll/design/inv_hv.sym
** sch_path: .fetched/sg13g2-pll/design/inv_hv.sch
.subckt inv_hv A Y VDD VSS
*.ipin A
*.opin Y
*.iopin VDD
*.iopin VSS
XMP Y A VDD VDD sg13_hv_pmos w=5u l=0.5u ng=1 m=1
XMN Y A VSS VSS sg13_hv_nmos w=2u l=0.5u ng=1 m=1
.ends

* expanding   symbol:  nor2_hv.sym # of pins=5
** sym_path: .fetched/sg13g2-pll/design/nor2_hv.sym
** sch_path: .fetched/sg13g2-pll/design/nor2_hv.sch
.subckt nor2_hv A B Y VDD VSS
*.ipin A
*.ipin B
*.opin Y
*.iopin VDD
*.iopin VSS
XMP1 midp A VDD VDD sg13_hv_pmos w=5u l=0.5u ng=1 m=1
XMP2 Y B midp VDD sg13_hv_pmos w=5u l=0.5u ng=1 m=1
XMN1 Y A VSS VSS sg13_hv_nmos w=2u l=0.5u ng=1 m=1
XMN2 Y B VSS VSS sg13_hv_nmos w=2u l=0.5u ng=1 m=1
.ends

* expanding   symbol:  nand2_hv.sym # of pins=5
** sym_path: .fetched/sg13g2-pll/design/nand2_hv.sym
** sch_path: .fetched/sg13g2-pll/design/nand2_hv.sch
.subckt nand2_hv A1 A2 Y VDD VSS
*.opin Y
*.ipin A1
*.ipin A2
*.iopin VDD
*.iopin VSS
XMP1 Y A1 VDD VDD sg13_hv_pmos w=5u l=0.5u ng=1 m=1
XMP2 Y A2 VDD VDD sg13_hv_pmos w=5u l=0.5u ng=1 m=1
XMN1 Y A1 mid1 VSS sg13_hv_nmos w=2u l=0.5u ng=1 m=1
XMN2 mid1 A2 VSS VSS sg13_hv_nmos w=2u l=0.5u ng=1 m=1
.ends

* expanding   symbol:  nand3_hv.sym # of pins=6
** sym_path: .fetched/sg13g2-pll/design/nand3_hv.sym
** sch_path: .fetched/sg13g2-pll/design/nand3_hv.sch
.subckt nand3_hv A1 A2 A3 Y VDD VSS
*.opin Y
*.ipin A1
*.ipin A2
*.ipin A3
*.iopin VDD
*.iopin VSS
XMP1 Y A1 VDD VDD sg13_hv_pmos w=5u l=0.5u ng=1 m=1
XMP2 Y A2 VDD VDD sg13_hv_pmos w=5u l=0.5u ng=1 m=1
XMP3 Y A3 VDD VDD sg13_hv_pmos w=5u l=0.5u ng=1 m=1
XMN1 Y A1 mid1 VSS sg13_hv_nmos w=2u l=0.5u ng=1 m=1
XMN2 mid1 A2 mid2 VSS sg13_hv_nmos w=2u l=0.5u ng=1 m=1
XMN3 mid2 A3 VSS VSS sg13_hv_nmos w=2u l=0.5u ng=1 m=1
.ends

* expanding   symbol:  tgate_hv.sym # of pins=6
** sym_path: .fetched/sg13g2-pll/design/tgate_hv.sym
** sch_path: .fetched/sg13g2-pll/design/tgate_hv.sch
.subckt tgate_hv A NG PG Y VDD VSS
*.ipin A
*.opin Y
*.ipin NG
*.ipin PG
*.iopin VDD
*.iopin VSS
XMN A NG Y VSS sg13_hv_nmos w=2u l=0.5u ng=1 m=1
XMP Y PG A VDD sg13_hv_pmos w=5u l=0.5u ng=1 m=1
.ends

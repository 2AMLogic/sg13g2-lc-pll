* sg13g2-lc-pll :: mcounter -- generated by design/netlist.sh (klt netlist) from design/mcounter.sch
* do not edit by hand.
** sch_path: design/mcounter.sch
.subckt mcounter CK M0 M1 M2 M3 TC TCN VDD VSS
*.ipin CK
*.ipin M0
*.ipin M1
*.ipin M2
*.ipin M3
*.opin TC
*.opin TCN
*.iopin VDD
*.iopin VSS
XQ0 D0 CK q0 VDD VSS dff_tg_hv
XQ1 D1 CK q1 VDD VSS dff_tg_hv
XQ2 D2 CK q2 VDD VSS dff_tg_hv
XQ3 D3 CK q3 VDD VSS dff_tg_hv
XTC1 q1 q2 n12 VDD VSS nor2_hv
XTC2 q3 q3b VDD VSS inv_hv
XTC3 q0 n12 q3b TCN VDD VSS nand3_hv
XTC4 TCN TC VDD VSS inv_hv
XD0 q0 dec0 VDD VSS inv_hv
XD1 q1 dec0 dec1 VDD VSS xor2_hv
XD2A q1 q0 n10 VDD VSS nor2_hv
XD2 q2 n10 dec2 VDD VSS xor2_hv
XD3A n10 n10b VDD VSS inv_hv
XD3B q2 n10b n210 VDD VSS nor2_hv
XD3 q3 n210 dec3 VDD VSS xor2_hv
XNL0A dec0 TCN L0_na VDD VSS nand2_hv
XNL0B M0 TC L0_nb VDD VSS nand2_hv
XNL0Y L0_na L0_nb D0 VDD VSS nand2_hv
XNL1A dec1 TCN L1_na VDD VSS nand2_hv
XNL1B M1 TC L1_nb VDD VSS nand2_hv
XNL1Y L1_na L1_nb D1 VDD VSS nand2_hv
XNL2A dec2 TCN L2_na VDD VSS nand2_hv
XNL2B M2 TC L2_nb VDD VSS nand2_hv
XNL2Y L2_na L2_nb D2 VDD VSS nand2_hv
XNL3A dec3 TCN L3_na VDD VSS nand2_hv
XNL3B M3 TC L3_nb VDD VSS nand2_hv
XNL3Y L3_na L3_nb D3 VDD VSS nand2_hv
.ends

* expanding   symbol:  dff_tg_hv.sym # of pins=5
** sym_path: .fetched/sg13g2-pll/design/dff_tg_hv.sym
** sch_path: .fetched/sg13g2-pll/design/dff_tg_hv.sch
.subckt dff_tg_hv D CLK Q VDD VSS
*.ipin D
*.ipin CLK
*.opin Q
*.iopin VDD
*.iopin VSS
XICLK CLK CLKB VDD VSS inv_hv
XICKBB CLKB CKBB VDD VSS inv_hv
XTG1 D CLKB CKBB M VDD VSS tgate_hv
XIM M MB VDD VSS inv_hv
XIMF MB MFB VDD VSS inv_hv
XTGFBM MFB CKBB CLKB M VDD VSS tgate_hv
XTG2 M CKBB CLKB S VDD VSS tgate_hv
XIS S SB VDD VSS inv_hv
XISF SB SFB VDD VSS inv_hv
XTGFBS SFB CLKB CKBB S VDD VSS tgate_hv
XBQ SB Q VDD VSS inv_hv
.ends

* expanding   symbol:  nor2_hv.sym # of pins=5
** sym_path: .fetched/sg13g2-pll/design/nor2_hv.sym
** sch_path: .fetched/sg13g2-pll/design/nor2_hv.sch
.subckt nor2_hv A B Y VDD VSS
*.ipin A
*.ipin B
*.opin Y
*.iopin VDD
*.iopin VSS
XMP1 midp A VDD VDD sg13_hv_pmos w=5u l=0.5u ng=1 m=1
XMP2 Y B midp VDD sg13_hv_pmos w=5u l=0.5u ng=1 m=1
XMN1 Y A VSS VSS sg13_hv_nmos w=2u l=0.5u ng=1 m=1
XMN2 Y B VSS VSS sg13_hv_nmos w=2u l=0.5u ng=1 m=1
.ends

* expanding   symbol:  inv_hv.sym # of pins=4
** sym_path: .fetched/sg13g2-pll/design/inv_hv.sym
** sch_path: .fetched/sg13g2-pll/design/inv_hv.sch
.subckt inv_hv A Y VDD VSS
*.ipin A
*.opin Y
*.iopin VDD
*.iopin VSS
XMP Y A VDD VDD sg13_hv_pmos w=5u l=0.5u ng=1 m=1
XMN Y A VSS VSS sg13_hv_nmos w=2u l=0.5u ng=1 m=1
.ends

* expanding   symbol:  nand3_hv.sym # of pins=6
** sym_path: .fetched/sg13g2-pll/design/nand3_hv.sym
** sch_path: .fetched/sg13g2-pll/design/nand3_hv.sch
.subckt nand3_hv A1 A2 A3 Y VDD VSS
*.opin Y
*.ipin A1
*.ipin A2
*.ipin A3
*.iopin VDD
*.iopin VSS
XMP1 Y A1 VDD VDD sg13_hv_pmos w=5u l=0.5u ng=1 m=1
XMP2 Y A2 VDD VDD sg13_hv_pmos w=5u l=0.5u ng=1 m=1
XMP3 Y A3 VDD VDD sg13_hv_pmos w=5u l=0.5u ng=1 m=1
XMN1 Y A1 mid1 VSS sg13_hv_nmos w=2u l=0.5u ng=1 m=1
XMN2 mid1 A2 mid2 VSS sg13_hv_nmos w=2u l=0.5u ng=1 m=1
XMN3 mid2 A3 VSS VSS sg13_hv_nmos w=2u l=0.5u ng=1 m=1
.ends

* expanding   symbol:  xor2_hv.sym # of pins=5
** sym_path: .fetched/sg13g2-pll/design/xor2_hv.sym
** sch_path: .fetched/sg13g2-pll/design/xor2_hv.sch
.subckt xor2_hv A B Y VDD VSS
*.ipin A
*.ipin B
*.opin Y
*.iopin VDD
*.iopin VSS
XN1 A B n1 VDD VSS nand2_hv
XN2 A n1 n2 VDD VSS nand2_hv
XN3 B n1 n3 VDD VSS nand2_hv
XN4 n2 n3 Y VDD VSS nand2_hv
.ends

* expanding   symbol:  nand2_hv.sym # of pins=5
** sym_path: .fetched/sg13g2-pll/design/nand2_hv.sym
** sch_path: .fetched/sg13g2-pll/design/nand2_hv.sch
.subckt nand2_hv A1 A2 Y VDD VSS
*.opin Y
*.ipin A1
*.ipin A2
*.iopin VDD
*.iopin VSS
XMP1 Y A1 VDD VDD sg13_hv_pmos w=5u l=0.5u ng=1 m=1
XMP2 Y A2 VDD VDD sg13_hv_pmos w=5u l=0.5u ng=1 m=1
XMN1 Y A1 mid1 VSS sg13_hv_nmos w=2u l=0.5u ng=1 m=1
XMN2 mid1 A2 VSS VSS sg13_hv_nmos w=2u l=0.5u ng=1 m=1
.ends

* expanding   symbol:  tgate_hv.sym # of pins=6
** sym_path: .fetched/sg13g2-pll/design/tgate_hv.sym
** sch_path: .fetched/sg13g2-pll/design/tgate_hv.sch
.subckt tgate_hv A NG PG Y VDD VSS
*.ipin A
*.opin Y
*.ipin NG
*.ipin PG
*.iopin VDD
*.iopin VSS
XMN A NG Y VSS sg13_hv_nmos w=2u l=0.5u ng=1 m=1
XMP Y PG A VDD sg13_hv_pmos w=5u l=0.5u ng=1 m=1
.ends

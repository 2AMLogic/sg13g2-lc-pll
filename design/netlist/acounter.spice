* sg13g2-lc-pll :: acounter -- generated by design/netlist.sh (klt netlist) from design/acounter.sch
* do not edit by hand.
** sch_path: design/acounter.sch
.subckt acounter CK TC TCN A0 A1 MC VDD VSS
*.ipin CK
*.ipin TC
*.ipin TCN
*.ipin A0
*.ipin A1
*.opin MC
*.iopin VDD
*.iopin VSS
XQ0 D0 CK s0 VDD VSS dff_tg_hv
XQ1 D1 CK s1 VDD VSS dff_tg_hv
XZ1 s0 s1 zb VDD VSS nor2_hv
XZ2 zb MC VDD VSS inv_hv
XD0 s0 MC dec0 VDD VSS xor2_hv
XD1A s0 zb brw VDD VSS nor2_hv
XD1 s1 brw dec1 VDD VSS xor2_hv
XNL0A dec0 TCN L0_na VDD VSS nand2_hv
XNL0B A0 TC L0_nb VDD VSS nand2_hv
XNL0Y L0_na L0_nb D0 VDD VSS nand2_hv
XNL1A dec1 TCN L1_na VDD VSS nand2_hv
XNL1B A1 TC L1_nb VDD VSS nand2_hv
XNL1Y L1_na L1_nb D1 VDD VSS nand2_hv
.ends

* expanding   symbol:  dff_tg_hv.sym # of pins=5
** sym_path: .fetched/sg13g2-pll/design/dff_tg_hv.sym
** sch_path: .fetched/sg13g2-pll/design/dff_tg_hv.sch
.subckt dff_tg_hv D CLK Q VDD VSS
*.ipin D
*.ipin CLK
*.opin Q
*.iopin VDD
*.iopin VSS
XICLK CLK CLKB VDD VSS inv_hv
XICKBB CLKB CKBB VDD VSS inv_hv
XTG1 D CLKB CKBB M VDD VSS tgate_hv
XIM M MB VDD VSS inv_hv
XIMF MB MFB VDD VSS inv_hv
XTGFBM MFB CKBB CLKB M VDD VSS tgate_hv
XTG2 M CKBB CLKB S VDD VSS tgate_hv
XIS S SB VDD VSS inv_hv
XISF SB SFB VDD VSS inv_hv
XTGFBS SFB CLKB CKBB S VDD VSS tgate_hv
XBQ SB Q VDD VSS inv_hv
.ends

* expanding   symbol:  nor2_hv.sym # of pins=5
** sym_path: .fetched/sg13g2-pll/design/nor2_hv.sym
** sch_path: .fetched/sg13g2-pll/design/nor2_hv.sch
.subckt nor2_hv A B Y VDD VSS
*.ipin A
*.ipin B
*.opin Y
*.iopin VDD
*.iopin VSS
XMP1 midp A VDD VDD sg13_hv_pmos w=5u l=0.5u ng=1 m=1
XMP2 Y B midp VDD sg13_hv_pmos w=5u l=0.5u ng=1 m=1
XMN1 Y A VSS VSS sg13_hv_nmos w=2u l=0.5u ng=1 m=1
XMN2 Y B VSS VSS sg13_hv_nmos w=2u l=0.5u ng=1 m=1
.ends

* expanding   symbol:  inv_hv.sym # of pins=4
** sym_path: .fetched/sg13g2-pll/design/inv_hv.sym
** sch_path: .fetched/sg13g2-pll/design/inv_hv.sch
.subckt inv_hv A Y VDD VSS
*.ipin A
*.opin Y
*.iopin VDD
*.iopin VSS
XMP Y A VDD VDD sg13_hv_pmos w=5u l=0.5u ng=1 m=1
XMN Y A VSS VSS sg13_hv_nmos w=2u l=0.5u ng=1 m=1
.ends

* expanding   symbol:  xor2_hv.sym # of pins=5
** sym_path: .fetched/sg13g2-pll/design/xor2_hv.sym
** sch_path: .fetched/sg13g2-pll/design/xor2_hv.sch
.subckt xor2_hv A B Y VDD VSS
*.ipin A
*.ipin B
*.opin Y
*.iopin VDD
*.iopin VSS
XN1 A B n1 VDD VSS nand2_hv
XN2 A n1 n2 VDD VSS nand2_hv
XN3 B n1 n3 VDD VSS nand2_hv
XN4 n2 n3 Y VDD VSS nand2_hv
.ends

* expanding   symbol:  nand2_hv.sym # of pins=5
** sym_path: .fetched/sg13g2-pll/design/nand2_hv.sym
** sch_path: .fetched/sg13g2-pll/design/nand2_hv.sch
.subckt nand2_hv A1 A2 Y VDD VSS
*.opin Y
*.ipin A1
*.ipin A2
*.iopin VDD
*.iopin VSS
XMP1 Y A1 VDD VDD sg13_hv_pmos w=5u l=0.5u ng=1 m=1
XMP2 Y A2 VDD VDD sg13_hv_pmos w=5u l=0.5u ng=1 m=1
XMN1 Y A1 mid1 VSS sg13_hv_nmos w=2u l=0.5u ng=1 m=1
XMN2 mid1 A2 VSS VSS sg13_hv_nmos w=2u l=0.5u ng=1 m=1
.ends

* expanding   symbol:  tgate_hv.sym # of pins=6
** sym_path: .fetched/sg13g2-pll/design/tgate_hv.sym
** sch_path: .fetched/sg13g2-pll/design/tgate_hv.sch
.subckt tgate_hv A NG PG Y VDD VSS
*.ipin A
*.opin Y
*.ipin NG
*.ipin PG
*.iopin VDD
*.iopin VSS
XMN A NG Y VSS sg13_hv_nmos w=2u l=0.5u ng=1 m=1
XMP Y PG A VDD sg13_hv_pmos w=5u l=0.5u ng=1 m=1
.ends

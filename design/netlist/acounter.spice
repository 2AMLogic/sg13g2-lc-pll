* sg13g2-lc-pll :: acounter -- generated by design/netlist.sh (klt netlist) from design/acounter.sch
* do not edit by hand.
** sch_path: design/acounter.sch
.subckt acounter CK TC TCN A0 A1 MC VDD VSS
*.ipin CK
*.ipin TC
*.ipin TCN
*.ipin A0
*.ipin A1
*.opin MC
*.iopin VDD
*.iopin VSS
XQ0 D0 CK s0 VDD VSS dff_tg_hv
XQ1 D1 CK s1 VDD VSS dff_tg_hv
XQM DM CK MC VDD VSS dff_tg_hv
XS0 s0 s0n VDD VSS inv_hv
XL0A TCN s1 s0n l0a VDD VSS nand3_hv
XL0B A0 TC l0b VDD VSS nand2_hv
XL0Y l0a l0b D0 VDD VSS nand2_hv
XL1A TCN s1 s0 l1a VDD VSS nand3_hv
XL1B A1 TC l1b VDD VSS nand2_hv
XL1Y l1a l1b D1 VDD VSS nand2_hv
XNA0 A0 A0n VDD VSS inv_hv
XNA1 A1 A1n VDD VSS inv_hv
XNZ A0n A1n anz VDD VSS nand2_hv
XMA TC anz m1 VDD VSS nand2_hv
XMB TCN s1 m2 VDD VSS nand2_hv
XMY m1 m2 DM VDD VSS nand2_hv
.ends

* expanding   symbol:  dff_tg_hv.sym # of pins=5
** sym_path: .fetched/sg13g2-pll/design/dff_tg_hv.sym
** sch_path: .fetched/sg13g2-pll/design/dff_tg_hv.sch
.subckt dff_tg_hv D CLK Q VDD VSS
*.ipin D
*.ipin CLK
*.opin Q
*.iopin VDD
*.iopin VSS
XICLK CLK CLKB VDD VSS inv_hv
XICKBB CLKB CKBB VDD VSS inv_hv
XTG1 D CLKB CKBB M VDD VSS tgate_hv
XIM M MB VDD VSS inv_hv
XIMF MB MFB VDD VSS inv_hv
XTGFBM MFB CKBB CLKB M VDD VSS tgate_hv
XTG2 M CKBB CLKB S VDD VSS tgate_hv
XIS S SB VDD VSS inv_hv
XISF SB SFB VDD VSS inv_hv
XTGFBS SFB CLKB CKBB S VDD VSS tgate_hv
XBQ SB Q VDD VSS inv_hv
.ends

* expanding   symbol:  inv_hv.sym # of pins=4
** sym_path: .fetched/sg13g2-pll/design/inv_hv.sym
** sch_path: .fetched/sg13g2-pll/design/inv_hv.sch
.subckt inv_hv A Y VDD VSS
*.ipin A
*.opin Y
*.iopin VDD
*.iopin VSS
XMP Y A VDD VDD sg13_hv_pmos w=5u l=0.5u ng=1 m=1
XMN Y A VSS VSS sg13_hv_nmos w=2u l=0.5u ng=1 m=1
.ends

* expanding   symbol:  nand3_hv.sym # of pins=6
** sym_path: .fetched/sg13g2-pll/design/nand3_hv.sym
** sch_path: .fetched/sg13g2-pll/design/nand3_hv.sch
.subckt nand3_hv A1 A2 A3 Y VDD VSS
*.opin Y
*.ipin A1
*.ipin A2
*.ipin A3
*.iopin VDD
*.iopin VSS
XMP1 Y A1 VDD VDD sg13_hv_pmos w=5u l=0.5u ng=1 m=1
XMP2 Y A2 VDD VDD sg13_hv_pmos w=5u l=0.5u ng=1 m=1
XMP3 Y A3 VDD VDD sg13_hv_pmos w=5u l=0.5u ng=1 m=1
XMN1 Y A1 mid1 VSS sg13_hv_nmos w=2u l=0.5u ng=1 m=1
XMN2 mid1 A2 mid2 VSS sg13_hv_nmos w=2u l=0.5u ng=1 m=1
XMN3 mid2 A3 VSS VSS sg13_hv_nmos w=2u l=0.5u ng=1 m=1
.ends

* expanding   symbol:  nand2_hv.sym # of pins=5
** sym_path: .fetched/sg13g2-pll/design/nand2_hv.sym
** sch_path: .fetched/sg13g2-pll/design/nand2_hv.sch
.subckt nand2_hv A1 A2 Y VDD VSS
*.opin Y
*.ipin A1
*.ipin A2
*.iopin VDD
*.iopin VSS
XMP1 Y A1 VDD VDD sg13_hv_pmos w=5u l=0.5u ng=1 m=1
XMP2 Y A2 VDD VDD sg13_hv_pmos w=5u l=0.5u ng=1 m=1
XMN1 Y A1 mid1 VSS sg13_hv_nmos w=2u l=0.5u ng=1 m=1
XMN2 mid1 A2 VSS VSS sg13_hv_nmos w=2u l=0.5u ng=1 m=1
.ends

* expanding   symbol:  tgate_hv.sym # of pins=6
** sym_path: .fetched/sg13g2-pll/design/tgate_hv.sym
** sch_path: .fetched/sg13g2-pll/design/tgate_hv.sch
.subckt tgate_hv A NG PG Y VDD VSS
*.ipin A
*.opin Y
*.ipin NG
*.ipin PG
*.iopin VDD
*.iopin VSS
XMN A NG Y VSS sg13_hv_nmos w=2u l=0.5u ng=1 m=1
XMP Y PG A VDD sg13_hv_pmos w=5u l=0.5u ng=1 m=1
.ends

* sg13g2-lc-pll :: cml2cmos -- generated by design/netlist.sh (klt netlist) from design/cml2cmos.sch
* do not edit by hand.
** sch_path: design/cml2cmos.sch
.subckt cml2cmos INP INN IREF CK VDD VSS
*.ipin INP
*.ipin INN
*.ipin IREF
*.opin CK
*.iopin VDD
*.iopin VSS
XQT tail IREF te VSS npn13G2v Nx=4 El=1
RT te VSS 600 m=1
XCC1 INP gp cap_cmim w=14u l=14u m=1
XCC2 INN gn cap_cmim w=14u l=14u m=1
RB1 vb gp 50k m=1
RB2 vb gn 50k m=1
RV1 VDD vb 50k m=1
RV2 vb VSS 50k m=1
XM1 d1 gp tail VSS sg13_hv_nmos w=10u l=0.5u ng=1 m=1
XM2 cmo gn tail VSS sg13_hv_nmos w=10u l=0.5u ng=1 m=1
XP1 d1 d1 VDD VDD sg13_hv_pmos w=10u l=0.5u ng=1 m=1
XP2 cmo d1 VDD VDD sg13_hv_pmos w=10u l=0.5u ng=1 m=1
XI1 cmo cmob VDD VSS inv_hv
XI2 cmob CK VDD VSS inv_hv
.ends

* expanding   symbol:  inv_hv.sym # of pins=4
** sym_path: .fetched/sg13g2-pll/design/inv_hv.sym
** sch_path: .fetched/sg13g2-pll/design/inv_hv.sch
.subckt inv_hv A Y VDD VSS
*.ipin A
*.opin Y
*.iopin VDD
*.iopin VSS
XMP Y A VDD VDD sg13_hv_pmos w=5u l=0.5u ng=1 m=1
XMN Y A VSS VSS sg13_hv_nmos w=2u l=0.5u ng=1 m=1
.ends
